* Gate-level netlist from Magic extract of puzzle
* Standard cells are black boxes (no transistors).
* Fill/decap/tap/via instances omitted.

.subckt sky130_fd_sc_hd__nor4_2 C D Y A B VGND VPWR VPB VNB
.ends

.subckt sky130_fd_sc_hd__or2_2 B X A VPWR VGND VPB VNB
.ends

.subckt sky130_fd_sc_hd__and2b_2 X B A_N VPWR VGND VPB VNB
.ends

.subckt sky130_fd_sc_hd__o31ai_2 A1 Y B1 A3 A2 VGND VPWR VPB VNB
.ends

.subckt sky130_fd_sc_hd__a31o_2 X B1 A3 A1 A2 VGND VPWR VPB VNB
.ends

.subckt sky130_fd_sc_hd__and3_2 B X A C VPWR VGND VPB VNB
.ends

.subckt sky130_fd_sc_hd__nand4_2 B A Y D C VGND VPWR VPB VNB
.ends

.subckt sky130_fd_sc_hd__or3_2 A B X C VGND VPWR VPB VNB
.ends

.subckt sky130_fd_sc_hd__xnor2_2 Y A B VGND VPWR VPB VNB
.ends

.subckt sky130_fd_sc_hd__and4bb_2 A_N C B_N X D VGND VPWR VPB VNB
.ends

.subckt sky130_fd_sc_hd__clkbuf_8 X A VGND VPWR VPB VNB
.ends

.subckt sky130_fd_sc_hd__nor3b_2 C_N Y A B VGND VPWR VPB VNB
.ends

.subckt sky130_fd_sc_hd__mux2_1 S A1 A0 X VGND VPWR VPB VNB
.ends

.subckt sky130_fd_sc_hd__a21o_2 X B1 A1 A2 VGND VPWR VPB VNB
.ends

.subckt sky130_fd_sc_hd__a211oi_2 A2 C1 B1 Y A1 VPWR VGND VPB VNB
.ends

.subckt sky130_fd_sc_hd__a22oi_2 A1 A2 B1 B2 Y VPWR VGND VPB VNB
.ends

.subckt sky130_fd_sc_hd__o221a_2 B2 A2 X B1 C1 A1 VGND VPWR VPB VNB
.ends

.subckt sky130_fd_sc_hd__and4_2 X C A B D VGND VPWR VPB VNB
.ends

.subckt sky130_fd_sc_hd__a21oi_2 B1 A2 A1 Y VGND VPWR VPB VNB
.ends

.subckt sky130_fd_sc_hd__o211a_2 C1 B1 A2 A1 X VPWR VGND VPB VNB
.ends

.subckt sky130_fd_sc_hd__or4b_2 C A X B D_N VPWR VGND VPB VNB
.ends

.subckt sky130_fd_sc_hd__dfrtp_2 Q RESET_B D CLK VGND VPWR VPB VNB
.ends

.subckt sky130_fd_sc_hd__o2bb2a_2 A1_N X A2_N B2 B1 VGND VPWR VPB VNB
.ends

.subckt sky130_fd_sc_hd__xor2_2 X B A VPWR VGND VPB VNB
.ends

.subckt sky130_fd_sc_hd__nand2b_2 B Y A_N VGND VPWR VPB VNB
.ends

.subckt sky130_fd_sc_hd__o211ai_2 A1 A2 B1 Y C1 VGND VPWR VPB VNB
.ends

.subckt sky130_fd_sc_hd__or4_2 C A X B D VPWR VGND VPB VNB
.ends

.subckt sky130_fd_sc_hd__clkbuf_4 X A VGND VPWR VPB VNB
.ends

.subckt sky130_fd_sc_hd__inv_2 A Y VPWR VGND VPB VNB
.ends

.subckt sky130_fd_sc_hd__a221oi_2 B2 C1 A2 A1 B1 Y VGND VPWR VPB VNB
.ends

.subckt sky130_fd_sc_hd__nand2_2 Y A B VGND VPWR VPB VNB
.ends

.subckt sky130_fd_sc_hd__a21bo_2 B1_N A2 X A1 VGND VPWR VPB VNB
.ends

.subckt sky130_fd_sc_hd__a31oi_2 A3 B1 Y A1 A2 VPWR VGND VPB VNB
.ends

.subckt sky130_fd_sc_hd__o311a_2 X A2 A3 A1 B1 C1 VPWR VGND VPB VNB
.ends

.subckt sky130_fd_sc_hd__o32a_2 B1 B2 A3 A2 A1 X VGND VPWR VPB VNB
.ends

.subckt sky130_fd_sc_hd__a21boi_2 B1_N A2 A1 Y VPWR VGND VPB VNB
.ends

.subckt sky130_fd_sc_hd__o22a_2 A2 X B1 A1 B2 VGND VPWR VPB VNB
.ends

.subckt sky130_fd_sc_hd__and4b_2 X A_N D C B VPWR VGND VPB VNB
.ends

.subckt sky130_fd_sc_hd__nor3_2 C Y A B VGND VPWR VPB VNB
.ends

.subckt sky130_fd_sc_hd__a221o_2 X B1 A1 B2 A2 VGND VPWR C1 VPB VNB
.ends

.subckt sky130_fd_sc_hd__o21a_2 A1 B1 A2 X VGND VPWR VPB VNB
.ends

.subckt sky130_fd_sc_hd__and2_2 A X B VPWR VGND VPB VNB
.ends

.subckt sky130_fd_sc_hd__a211o_2 X A2 A1 B1 C1 VGND VPWR VPB VNB
.ends

.subckt sky130_fd_sc_hd__dfxtp_2 Q CLK D VPWR VGND VPB VNB
.ends

.subckt sky130_fd_sc_hd__buf_2 VPWR VGND X A VPB VNB
.ends

.subckt sky130_fd_sc_hd__or3b_2 A B C_N X VPWR VGND VPB VNB
.ends

.subckt sky130_fd_sc_hd__o21bai_2 B1_N Y A2 A1 VGND VPWR VPB VNB
.ends

.subckt sky130_fd_sc_hd__a41oi_2 A4 A3 A2 B1 A1 Y VPWR VGND VPB VNB
.ends

.subckt sky130_fd_sc_hd__a32o_2 B2 X A2 A3 A1 B1 VGND VPWR VPB VNB
.ends

.subckt sky130_fd_sc_hd__a22o_2 A1 A2 X B2 B1 VPWR VGND VPB VNB
.ends

.subckt sky130_fd_sc_hd__a311o_2 X C1 B1 A1 A2 A3 VGND VPWR VPB VNB
.ends

.subckt sky130_fd_sc_hd__dfstp_2 Q D VPWR SET_B CLK VGND VPB VNB
.ends

.subckt sky130_fd_sc_hd__clkbuf_16 X A VGND VPWR VPB VNB
.ends

.subckt sky130_fd_sc_hd__o31a_2 X A1 A2 B1 A3 VGND VPWR VPB VNB
.ends

.subckt sky130_fd_sc_hd__and3b_2 B X A_N C VGND VPWR VPB VNB
.ends

.subckt sky130_fd_sc_hd__nor2_2 B Y A VGND VPWR VPB VNB
.ends

.subckt sky130_fd_sc_hd__nor4b_2 D_N Y C A B VGND VPWR VPB VNB
.ends

.subckt sky130_fd_sc_hd__conb_1 LO HI VGND VPWR VPB VNB
.ends

.subckt sky130_fd_sc_hd__o22ai_2 B2 B1 Y A1 A2 VGND VPWR VPB VNB
.ends

.subckt sky130_fd_sc_hd__o21ai_2 B1 Y A2 A1 VGND VPWR VPB VNB
.ends

.subckt sky130_fd_sc_hd__nand3b_2 Y C A_N B VGND VPWR VPB VNB
.ends

.subckt sky130_fd_sc_hd__a2111oi_2 D1 C1 A2 A1 Y B1 VGND VPWR VPB VNB
.ends

.subckt sky130_fd_sc_hd__nand3_2 A Y B C VGND VPWR VPB VNB
.ends

.subckt sky130_fd_sc_hd__o32ai_2 A1 B1 A2 A3 Y B2 VGND VPWR VPB VNB
.ends

.subckt sky130_fd_sc_hd__o21ba_2 B1_N A1 X A2 VGND VPWR VPB VNB
.ends

.subckt sky130_fd_sc_hd__or4bb_2 A X B D_N C_N VPWR VGND VPB VNB
.ends

.subckt puzzle I O[0] O[1] O[2] O[3] O[4] O[5] O[6] O[7] clk enable rst_n success VGND VPWR
Xsky130_fd_sc_hd__nor4_2_0 sky130_fd_sc_hd__or4b_2_2/C sky130_fd_sc_hd__or4b_2_3/C sky130_fd_sc_hd__nor4_2_0/Y sky130_fd_sc_hd__or4b_2_3/A sky130_fd_sc_hd__or4b_2_3/B VGND VPWR sky130_fd_sc_hd__nor4_2_0/VPB VGND sky130_fd_sc_hd__nor4_2
Xsky130_fd_sc_hd__or2_2_8 sky130_fd_sc_hd__or2_2_8/B sky130_fd_sc_hd__or2_2_8/X sky130_fd_sc_hd__or2_2_9/B VPWR VGND sky130_fd_sc_hd__or2_2_8/VPB VGND sky130_fd_sc_hd__or2_2
Xsky130_fd_sc_hd__and2b_2_3 sky130_fd_sc_hd__and4_2_1/A sky130_fd_sc_hd__and2b_2_3/B sky130_fd_sc_hd__nand4_2_1/C VPWR VGND VPWR VGND sky130_fd_sc_hd__and2b_2
Xsky130_fd_sc_hd__o31ai_2_1 sky130_fd_sc_hd__or3_2_3/A sky130_fd_sc_hd__o31ai_2_1/Y sky130_fd_sc_hd__nor2_2_5/A sky130_fd_sc_hd__or2_2_2/A sky130_fd_sc_hd__or3_2_3/B VGND VPWR VPWR VGND sky130_fd_sc_hd__o31ai_2
Xsky130_fd_sc_hd__a31o_2_17 sky130_fd_sc_hd__a31o_2_17/X sky130_fd_sc_hd__nand4_2_4/C sky130_fd_sc_hd__nand4_2_4/D I sky130_fd_sc_hd__inv_2_7/A VGND VPWR VPWR VGND sky130_fd_sc_hd__a31o_2
Xsky130_fd_sc_hd__and3_2_20 sky130_fd_sc_hd__o31a_2_10/X O[3] sky130_fd_sc_hd__or2_2_11/B sky130_fd_sc_hd__and3_2_25/C VPWR VGND VPWR VGND sky130_fd_sc_hd__and3_2
Xsky130_fd_sc_hd__nand4_2_12 sky130_fd_sc_hd__inv_2_7/A I sky130_fd_sc_hd__o21a_2_27/A2 sky130_fd_sc_hd__nand4_2_12/D sky130_fd_sc_hd__nand4_2_12/C VGND VPWR VPWR VGND sky130_fd_sc_hd__nand4_2
Xsky130_fd_sc_hd__or3_2_17 sky130_fd_sc_hd__or3_2_17/A sky130_fd_sc_hd__or3_2_17/B sky130_fd_sc_hd__or3_2_17/X sky130_fd_sc_hd__or3_2_17/C VGND VPWR VPWR VGND sky130_fd_sc_hd__or3_2
Xsky130_fd_sc_hd__a31o_2_9 sky130_fd_sc_hd__a31o_2_9/X sky130_fd_sc_hd__nor3_2_2/A sky130_fd_sc_hd__and4_2_4/D sky130_fd_sc_hd__and4_2_3/C sky130_fd_sc_hd__inv_2_10/A VGND VPWR VPWR VGND sky130_fd_sc_hd__a31o_2
Xsky130_fd_sc_hd__xnor2_2_24 sky130_fd_sc_hd__nor3b_2_0/B sky130_fd_sc_hd__xor2_2_16/A sky130_fd_sc_hd__xor2_2_19/X VGND VPWR VPWR VGND sky130_fd_sc_hd__xnor2_2
Xsky130_fd_sc_hd__and4bb_2_7 sky130_fd_sc_hd__or4b_2_3/A sky130_fd_sc_hd__or4b_2_2/C sky130_fd_sc_hd__or4b_2_3/C sky130_fd_sc_hd__nand4_2_4/D sky130_fd_sc_hd__or4b_2_3/B VGND VPWR VPWR VGND sky130_fd_sc_hd__and4bb_2
Xsky130_fd_sc_hd__xnor2_2_13 sky130_fd_sc_hd__xnor2_2_13/Y sky130_fd_sc_hd__xor2_2_17/B sky130_fd_sc_hd__a31o_2_15/X VGND VPWR VPWR VGND sky130_fd_sc_hd__xnor2_2
Xsky130_fd_sc_hd__clkbuf_8_15 sky130_fd_sc_hd__dfrtp_2_8/CLK sky130_fd_sc_hd__clkbuf_8_9/A VGND VPWR VPWR VGND sky130_fd_sc_hd__clkbuf_8
Xsky130_fd_sc_hd__nor3b_2_2 sky130_fd_sc_hd__nor3_2_3/B sky130_fd_sc_hd__nor3b_2_2/Y sky130_fd_sc_hd__nor3_2_3/A sky130_fd_sc_hd__nor3_2_3/C VGND VPWR VPWR VGND sky130_fd_sc_hd__nor3b_2
Xsky130_fd_sc_hd__clkbuf_8_1 sky130_fd_sc_hd__clkbuf_8_1/X sky130_fd_sc_hd__clkbuf_8_9/A VGND VPWR VPWR VGND sky130_fd_sc_hd__clkbuf_8
Xsky130_fd_sc_hd__mux2_1_4 sky130_fd_sc_hd__mux2_1_4/S sky130_fd_sc_hd__or2_2_4/A sky130_fd_sc_hd__or3_2_4/B sky130_fd_sc_hd__mux2_1_4/X VGND VPWR VPWR VGND sky130_fd_sc_hd__mux2_1
Xsky130_fd_sc_hd__a21o_2_8 sky130_fd_sc_hd__xor2_2_8/A sky130_fd_sc_hd__nor2_2_19/Y sky130_fd_sc_hd__xor2_2_2/A sky130_fd_sc_hd__a21o_2_8/A2 VGND VPWR VPWR VGND sky130_fd_sc_hd__a21o_2
Xsky130_fd_sc_hd__a211oi_2_0 sky130_fd_sc_hd__inv_2_9/A sky130_fd_sc_hd__xor2_2_11/B sky130_fd_sc_hd__a21oi_2_13/Y sky130_fd_sc_hd__dfrtp_2_43/D sky130_fd_sc_hd__inv_2_7/A VPWR VGND VPWR VGND sky130_fd_sc_hd__a211oi_2
Xsky130_fd_sc_hd__nor4_2_1 sky130_fd_sc_hd__or4_2_4/D sky130_fd_sc_hd__or4_2_4/C sky130_fd_sc_hd__nor4_2_1/Y sky130_fd_sc_hd__or4_2_4/B sky130_fd_sc_hd__or4_2_4/A VGND VPWR sky130_fd_sc_hd__nor4_2_1/VPB VGND sky130_fd_sc_hd__nor4_2
Xsky130_fd_sc_hd__a22oi_2_0 sky130_fd_sc_hd__or3b_2_0/A sky130_fd_sc_hd__inv_2_13/Y sky130_fd_sc_hd__or2_2_9/X sky130_fd_sc_hd__nand2_2_29/Y sky130_fd_sc_hd__a22oi_2_0/Y VPWR VGND VPWR VGND sky130_fd_sc_hd__a22oi_2
Xsky130_fd_sc_hd__or2_2_9 sky130_fd_sc_hd__or2_2_9/B sky130_fd_sc_hd__or2_2_9/X sky130_fd_sc_hd__or2_2_9/A VPWR VGND VPWR VGND sky130_fd_sc_hd__or2_2
Xsky130_fd_sc_hd__o221a_2_0 sky130_fd_sc_hd__or4_2_0/A sky130_fd_sc_hd__o21ai_2_2/Y sky130_fd_sc_hd__o221a_2_0/X sky130_fd_sc_hd__o21a_2_1/X sky130_fd_sc_hd__or4_2_0/B sky130_fd_sc_hd__or3_2_2/C VGND VPWR VPWR VGND sky130_fd_sc_hd__o221a_2
Xsky130_fd_sc_hd__and2b_2_4 sky130_fd_sc_hd__and4_2_1/D sky130_fd_sc_hd__o21a_2_8/A1 sky130_fd_sc_hd__nand4_2_2/C VPWR VGND sky130_fd_sc_hd__dfrtp_2_5/VPB VGND sky130_fd_sc_hd__and2b_2
Xsky130_fd_sc_hd__and4_2_0 sky130_fd_sc_hd__and4_2_0/X sky130_fd_sc_hd__and4_2_0/C sky130_fd_sc_hd__and4_2_0/A sky130_fd_sc_hd__and4_2_0/B sky130_fd_sc_hd__and4_2_0/D VGND VPWR sky130_fd_sc_hd__and4_2_0/VPB VGND sky130_fd_sc_hd__and4_2
Xsky130_fd_sc_hd__a31o_2_18 sky130_fd_sc_hd__a31o_2_18/X sky130_fd_sc_hd__nand4_2_7/C sky130_fd_sc_hd__nor4_2_1/Y I sky130_fd_sc_hd__inv_2_7/A VGND VPWR sky130_fd_sc_hd__nor4_2_1/VPB VGND sky130_fd_sc_hd__a31o_2
Xsky130_fd_sc_hd__and3_2_10 sky130_fd_sc_hd__and3_2_10/B sky130_fd_sc_hd__or4b_2_8/C sky130_fd_sc_hd__and3_2_10/A sky130_fd_sc_hd__and4_2_4/B VPWR VGND VPWR VGND sky130_fd_sc_hd__and3_2
Xsky130_fd_sc_hd__and3_2_21 sky130_fd_sc_hd__o31a_2_5/X O[4] sky130_fd_sc_hd__or2_2_11/B sky130_fd_sc_hd__and3_2_25/C VPWR VGND VPWR VGND sky130_fd_sc_hd__and3_2
Xsky130_fd_sc_hd__nand4_2_13 sky130_fd_sc_hd__inv_2_7/A I sky130_fd_sc_hd__o21a_2_25/A2 sky130_fd_sc_hd__nand4_2_13/D sky130_fd_sc_hd__nand4_2_13/C VGND VPWR VPWR VGND sky130_fd_sc_hd__nand4_2
Xsky130_fd_sc_hd__xnor2_2_25 sky130_fd_sc_hd__nor2_2_46/B sky130_fd_sc_hd__a22o_2_4/B2 sky130_fd_sc_hd__xor2_2_17/X VGND VPWR VPWR VGND sky130_fd_sc_hd__xnor2_2
Xsky130_fd_sc_hd__and4bb_2_8 sky130_fd_sc_hd__or4b_2_3/B sky130_fd_sc_hd__or4b_2_2/C sky130_fd_sc_hd__or4b_2_3/C sky130_fd_sc_hd__nand4_2_6/D sky130_fd_sc_hd__or4b_2_3/A VGND VPWR VPWR VGND sky130_fd_sc_hd__and4bb_2
Xsky130_fd_sc_hd__xnor2_2_14 sky130_fd_sc_hd__xnor2_2_14/Y sky130_fd_sc_hd__xor2_2_16/A sky130_fd_sc_hd__xnor2_2_14/B VGND VPWR VPWR VGND sky130_fd_sc_hd__xnor2_2
Xsky130_fd_sc_hd__nor3b_2_3 sky130_fd_sc_hd__nor3_2_3/C sky130_fd_sc_hd__nor3b_2_3/Y sky130_fd_sc_hd__nor3_2_3/A sky130_fd_sc_hd__nor3_2_3/B VGND VPWR VPWR VGND sky130_fd_sc_hd__nor3b_2
Xsky130_fd_sc_hd__clkbuf_8_2 sky130_fd_sc_hd__clkbuf_8_2/X sky130_fd_sc_hd__clkbuf_8_9/A VGND VPWR VPWR VGND sky130_fd_sc_hd__clkbuf_8
Xsky130_fd_sc_hd__mux2_1_5 sky130_fd_sc_hd__xor2_2_7/A sky130_fd_sc_hd__mux2_1_5/A1 sky130_fd_sc_hd__and3_2_7/X sky130_fd_sc_hd__mux2_1_5/X VGND VPWR VPWR VGND sky130_fd_sc_hd__mux2_1
Xsky130_fd_sc_hd__a21o_2_9 sky130_fd_sc_hd__a21o_2_9/X sky130_fd_sc_hd__xor2_2_4/A sky130_fd_sc_hd__xor2_2_9/A sky130_fd_sc_hd__inv_2_5/A VGND VPWR VPWR VGND sky130_fd_sc_hd__a21o_2
Xsky130_fd_sc_hd__a211oi_2_1 sky130_fd_sc_hd__a32o_2_3/B1 sky130_fd_sc_hd__or4b_2_8/A sky130_fd_sc_hd__or4b_2_8/C sky130_fd_sc_hd__nor3_2_3/A sky130_fd_sc_hd__inv_2_22/Y VPWR VGND VPWR VGND sky130_fd_sc_hd__a211oi_2
Xsky130_fd_sc_hd__o221a_2_1 sky130_fd_sc_hd__xnor2_2_21/Y sky130_fd_sc_hd__or2_2_10/X sky130_fd_sc_hd__o221a_2_1/X sky130_fd_sc_hd__nor2_2_46/A sky130_fd_sc_hd__o21ai_2_3/Y sky130_fd_sc_hd__xor2_2_16/A VGND VPWR VPWR VGND sky130_fd_sc_hd__o221a_2
Xsky130_fd_sc_hd__and2b_2_5 sky130_fd_sc_hd__xor2_2_6/B sky130_fd_sc_hd__o22ai_2_0/Y sky130_fd_sc_hd__and4bb_2_0/X VPWR VGND VPWR VGND sky130_fd_sc_hd__and2b_2
Xsky130_fd_sc_hd__a21oi_2_0 sky130_fd_sc_hd__or4_2_0/A sky130_fd_sc_hd__nor2_2_3/B sky130_fd_sc_hd__or3_2_3/B sky130_fd_sc_hd__a32o_2_1/B2 VGND VPWR VPWR VGND sky130_fd_sc_hd__a21oi_2
Xsky130_fd_sc_hd__and4_2_1 sky130_fd_sc_hd__and4_2_1/X sky130_fd_sc_hd__and4_2_1/C sky130_fd_sc_hd__and4_2_1/A sky130_fd_sc_hd__and4_2_1/B sky130_fd_sc_hd__and4_2_1/D VGND VPWR sky130_fd_sc_hd__and4_2_1/VPB VGND sky130_fd_sc_hd__and4_2
Xsky130_fd_sc_hd__a31o_2_19 sky130_fd_sc_hd__a31o_2_19/X sky130_fd_sc_hd__nand4_2_8/C sky130_fd_sc_hd__nand4_2_8/D I sky130_fd_sc_hd__inv_2_7/A VGND VPWR VPWR VGND sky130_fd_sc_hd__a31o_2
Xsky130_fd_sc_hd__o211a_2_0 sky130_fd_sc_hd__xor2_2_4/A sky130_fd_sc_hd__xor2_2_9/A sky130_fd_sc_hd__xor2_2_0/B sky130_fd_sc_hd__xor2_2_7/A sky130_fd_sc_hd__o211a_2_0/X VPWR VGND VPWR VGND sky130_fd_sc_hd__o211a_2
Xsky130_fd_sc_hd__and3_2_22 sky130_fd_sc_hd__o31a_2_8/X O[5] sky130_fd_sc_hd__or2_2_11/B sky130_fd_sc_hd__and3_2_25/C VPWR VGND sky130_fd_sc_hd__and3_2_22/VPB VGND sky130_fd_sc_hd__and3_2
Xsky130_fd_sc_hd__and3_2_11 sky130_fd_sc_hd__and4_2_3/B sky130_fd_sc_hd__and3_2_11/X sky130_fd_sc_hd__and4_2_3/A sky130_fd_sc_hd__inv_2_10/A VPWR VGND VPWR VGND sky130_fd_sc_hd__and3_2
Xsky130_fd_sc_hd__nand4_2_14 sky130_fd_sc_hd__or2_2_9/B sky130_fd_sc_hd__or2_2_8/B sky130_fd_sc_hd__and3_2_25/C sky130_fd_sc_hd__or3b_2_0/A sky130_fd_sc_hd__or2_2_9/A VGND VPWR VPWR VGND sky130_fd_sc_hd__nand4_2
Xsky130_fd_sc_hd__and4bb_2_9 sky130_fd_sc_hd__or4_2_4/B sky130_fd_sc_hd__or4_2_4/C sky130_fd_sc_hd__or4_2_4/D sky130_fd_sc_hd__nand4_2_9/D sky130_fd_sc_hd__or4_2_4/A VGND VPWR VPWR VGND sky130_fd_sc_hd__and4bb_2
Xsky130_fd_sc_hd__xnor2_2_15 sky130_fd_sc_hd__a22o_2_9/A1 sky130_fd_sc_hd__a22o_2_4/B2 sky130_fd_sc_hd__a22o_2_22/X VGND VPWR VPWR VGND sky130_fd_sc_hd__xnor2_2
Xsky130_fd_sc_hd__xnor2_2_26 sky130_fd_sc_hd__nor2_2_40/A sky130_fd_sc_hd__xnor2_2_26/A sky130_fd_sc_hd__xnor2_2_26/B VGND VPWR VPWR VGND sky130_fd_sc_hd__xnor2_2
Xsky130_fd_sc_hd__nor3b_2_4 sky130_fd_sc_hd__nor3_2_3/A sky130_fd_sc_hd__or3_2_17/B sky130_fd_sc_hd__nor3_2_3/B sky130_fd_sc_hd__nor3_2_3/C VGND VPWR VPWR VGND sky130_fd_sc_hd__nor3b_2
Xsky130_fd_sc_hd__clkbuf_8_3 sky130_fd_sc_hd__clkbuf_8_3/X sky130_fd_sc_hd__clkbuf_8_9/A VGND VPWR VPWR VGND sky130_fd_sc_hd__clkbuf_8
Xsky130_fd_sc_hd__mux2_1_6 sky130_fd_sc_hd__inv_2_7/Y sky130_fd_sc_hd__inv_2_8/Y sky130_fd_sc_hd__inv_2_9/A sky130_fd_sc_hd__mux2_1_6/X VGND VPWR VPWR VGND sky130_fd_sc_hd__mux2_1
Xsky130_fd_sc_hd__a211oi_2_2 sky130_fd_sc_hd__or2_2_9/A sky130_fd_sc_hd__or2_2_8/B sky130_fd_sc_hd__or2_2_9/B sky130_fd_sc_hd__or3_2_17/A sky130_fd_sc_hd__or3b_2_0/A VPWR VGND VPWR VGND sky130_fd_sc_hd__a211oi_2
Xsky130_fd_sc_hd__o221a_2_2 sky130_fd_sc_hd__o221a_2_2/B2 sky130_fd_sc_hd__nor2_2_32/B sky130_fd_sc_hd__o221a_2_2/X sky130_fd_sc_hd__nor2_2_32/Y sky130_fd_sc_hd__o221a_2_2/C1 sky130_fd_sc_hd__or2_2_8/X VGND VPWR VPWR VGND sky130_fd_sc_hd__o221a_2
Xsky130_fd_sc_hd__or4b_2_0 sky130_fd_sc_hd__or4b_2_3/C sky130_fd_sc_hd__or4b_2_3/A sky130_fd_sc_hd__or4_2_1/C sky130_fd_sc_hd__or4b_2_2/C sky130_fd_sc_hd__or4b_2_3/B VPWR VGND VPWR VGND sky130_fd_sc_hd__or4b_2
Xsky130_fd_sc_hd__and2b_2_6 sky130_fd_sc_hd__and2b_2_6/X sky130_fd_sc_hd__or3b_2_0/A sky130_fd_sc_hd__or2_2_9/B VPWR VGND VPWR VGND sky130_fd_sc_hd__and2b_2
Xsky130_fd_sc_hd__a21oi_2_1 sky130_fd_sc_hd__or3_2_0/X sky130_fd_sc_hd__and3_2_0/C sky130_fd_sc_hd__or2_2_4/A sky130_fd_sc_hd__o32a_2_0/A3 VGND VPWR VPWR VGND sky130_fd_sc_hd__a21oi_2
Xsky130_fd_sc_hd__and4_2_2 sky130_fd_sc_hd__inv_2_5/A sky130_fd_sc_hd__xor2_2_0/B sky130_fd_sc_hd__inv_2_9/A sky130_fd_sc_hd__inv_2_7/A sky130_fd_sc_hd__xor2_2_7/A VGND VPWR VPWR VGND sky130_fd_sc_hd__and4_2
Xsky130_fd_sc_hd__o211a_2_1 sky130_fd_sc_hd__nor2_2_5/A sky130_fd_sc_hd__or2_2_4/A sky130_fd_sc_hd__or2_2_2/A sky130_fd_sc_hd__or3_2_3/A sky130_fd_sc_hd__or3_2_4/C VPWR VGND VPWR VGND sky130_fd_sc_hd__o211a_2
Xsky130_fd_sc_hd__and3_2_23 sky130_fd_sc_hd__o31a_2_3/X O[7] sky130_fd_sc_hd__or2_2_11/B sky130_fd_sc_hd__and3_2_25/C VPWR VGND VPWR VGND sky130_fd_sc_hd__and3_2
Xsky130_fd_sc_hd__and3_2_12 sky130_fd_sc_hd__and3_2_12/B sky130_fd_sc_hd__and3_2_13/C sky130_fd_sc_hd__and3_2_12/A sky130_fd_sc_hd__and3_2_12/C VPWR VGND VPWR VGND sky130_fd_sc_hd__and3_2
Xsky130_fd_sc_hd__xnor2_2_16 sky130_fd_sc_hd__xnor2_2_26/B sky130_fd_sc_hd__xor2_2_20/A sky130_fd_sc_hd__xor2_2_17/B VGND VPWR VPWR VGND sky130_fd_sc_hd__xnor2_2
Xsky130_fd_sc_hd__xnor2_2_27 sky130_fd_sc_hd__o32a_2_2/A2 sky130_fd_sc_hd__or2_2_8/B sky130_fd_sc_hd__and3_2_16/X VGND VPWR VPWR VGND sky130_fd_sc_hd__xnor2_2
Xsky130_fd_sc_hd__clkbuf_8_4 sky130_fd_sc_hd__clkbuf_8_4/X sky130_fd_sc_hd__clkbuf_8_9/A VGND VPWR VPWR VGND sky130_fd_sc_hd__clkbuf_8
Xsky130_fd_sc_hd__dfrtp_2_80 sky130_fd_sc_hd__nand4_2_9/C rst_n sky130_fd_sc_hd__o21a_2_21/X sky130_fd_sc_hd__clkbuf_8_9/X VGND VPWR VPWR VGND sky130_fd_sc_hd__dfrtp_2
Xsky130_fd_sc_hd__mux2_1_7 sky130_fd_sc_hd__inv_2_8/A sky130_fd_sc_hd__or2_2_7/X sky130_fd_sc_hd__mux2_1_7/A0 sky130_fd_sc_hd__mux2_1_7/X VGND VPWR VPWR VGND sky130_fd_sc_hd__mux2_1
Xsky130_fd_sc_hd__o2bb2a_2_0 sky130_fd_sc_hd__or4_2_4/C sky130_fd_sc_hd__xnor2_2_8/B sky130_fd_sc_hd__xor2_2_1/B sky130_fd_sc_hd__xor2_2_9/A sky130_fd_sc_hd__nand2_2_2/Y VGND VPWR VPWR VGND sky130_fd_sc_hd__o2bb2a_2
Xsky130_fd_sc_hd__or4b_2_1 sky130_fd_sc_hd__or4b_2_3/C sky130_fd_sc_hd__or4b_2_3/B sky130_fd_sc_hd__or4_2_3/C sky130_fd_sc_hd__or4b_2_2/C sky130_fd_sc_hd__or4b_2_3/A VPWR VGND VPWR VGND sky130_fd_sc_hd__or4b_2
Xsky130_fd_sc_hd__xor2_2_20 sky130_fd_sc_hd__xor2_2_20/X sky130_fd_sc_hd__xor2_2_20/B sky130_fd_sc_hd__xor2_2_20/A VPWR VGND VPWR VGND sky130_fd_sc_hd__xor2_2
Xsky130_fd_sc_hd__and2b_2_7 sky130_fd_sc_hd__o31a_2_0/A1 sky130_fd_sc_hd__or2_2_9/B sky130_fd_sc_hd__or2_2_9/A VPWR VGND sky130_fd_sc_hd__o31a_2_0/VPB VGND sky130_fd_sc_hd__and2b_2
Xsky130_fd_sc_hd__a21oi_2_2 sky130_fd_sc_hd__or4_2_0/A sky130_fd_sc_hd__o21ba_2_0/X sky130_fd_sc_hd__or2_2_5/A sky130_fd_sc_hd__a21oi_2_2/Y VGND VPWR VPWR VGND sky130_fd_sc_hd__a21oi_2
Xsky130_fd_sc_hd__and4_2_3 sky130_fd_sc_hd__and4_2_3/X sky130_fd_sc_hd__and4_2_3/C sky130_fd_sc_hd__and4_2_3/A sky130_fd_sc_hd__and4_2_3/B sky130_fd_sc_hd__nor3_2_2/Y VGND VPWR VPWR VGND sky130_fd_sc_hd__and4_2
Xsky130_fd_sc_hd__o211a_2_2 sky130_fd_sc_hd__or3_2_7/X sky130_fd_sc_hd__nor2_2_20/Y sky130_fd_sc_hd__a31o_2_5/X sky130_fd_sc_hd__o311a_2_0/X sky130_fd_sc_hd__or4b_2_3/B VPWR VGND VPWR VGND sky130_fd_sc_hd__o211a_2
Xsky130_fd_sc_hd__and3_2_24 sky130_fd_sc_hd__o31a_2_7/X O[2] sky130_fd_sc_hd__or2_2_11/B sky130_fd_sc_hd__and3_2_25/C VPWR VGND VPWR VGND sky130_fd_sc_hd__and3_2
Xsky130_fd_sc_hd__and3_2_13 sky130_fd_sc_hd__and4_2_6/X sky130_fd_sc_hd__and4b_2_3/D sky130_fd_sc_hd__and4_2_5/X sky130_fd_sc_hd__and3_2_13/C VPWR VGND VPWR VGND sky130_fd_sc_hd__and3_2
Xsky130_fd_sc_hd__or2_2_10 sky130_fd_sc_hd__inv_2_7/A sky130_fd_sc_hd__or2_2_10/X sky130_fd_sc_hd__or2_2_10/A VPWR VGND VPWR VGND sky130_fd_sc_hd__or2_2
Xsky130_fd_sc_hd__xnor2_2_28 sky130_fd_sc_hd__xnor2_2_28/Y sky130_fd_sc_hd__or2_2_9/A sky130_fd_sc_hd__or3b_2_0/A VGND VPWR VPWR VGND sky130_fd_sc_hd__xnor2_2
Xsky130_fd_sc_hd__xnor2_2_17 sky130_fd_sc_hd__xnor2_2_26/A sky130_fd_sc_hd__xor2_2_14/B sky130_fd_sc_hd__xor2_2_19/A VGND VPWR VPWR VGND sky130_fd_sc_hd__xnor2_2
Xsky130_fd_sc_hd__clkbuf_8_5 sky130_fd_sc_hd__clkbuf_8_5/X sky130_fd_sc_hd__clkbuf_8_9/A VGND VPWR VPWR VGND sky130_fd_sc_hd__clkbuf_8
Xsky130_fd_sc_hd__dfrtp_2_70 sky130_fd_sc_hd__o21a_2_27/A1 rst_n sky130_fd_sc_hd__dfrtp_2_70/D sky130_fd_sc_hd__clkbuf_8_11/X VGND VPWR VPWR VGND sky130_fd_sc_hd__dfrtp_2
Xsky130_fd_sc_hd__dfrtp_2_81 success rst_n sky130_fd_sc_hd__a32o_2_4/X sky130_fd_sc_hd__dfxtp_2_2/CLK VGND VPWR VPWR VGND sky130_fd_sc_hd__dfrtp_2
Xsky130_fd_sc_hd__mux2_1_8 sky130_fd_sc_hd__inv_2_7/A sky130_fd_sc_hd__mux2_1_8/A1 sky130_fd_sc_hd__mux2_1_8/A0 sky130_fd_sc_hd__mux2_1_8/X VGND VPWR VPWR VGND sky130_fd_sc_hd__mux2_1
Xsky130_fd_sc_hd__or4b_2_2 sky130_fd_sc_hd__or4b_2_2/C sky130_fd_sc_hd__or4b_2_3/A sky130_fd_sc_hd__or4_2_2/C sky130_fd_sc_hd__or4b_2_3/B sky130_fd_sc_hd__or4b_2_3/C VPWR VGND VPWR VGND sky130_fd_sc_hd__or4b_2
Xsky130_fd_sc_hd__xor2_2_10 sky130_fd_sc_hd__xor2_2_10/X sky130_fd_sc_hd__and4_2_4/X sky130_fd_sc_hd__or3_2_8/C VPWR VGND VPWR VGND sky130_fd_sc_hd__xor2_2
Xsky130_fd_sc_hd__and2b_2_8 sky130_fd_sc_hd__and3_2_10/B sky130_fd_sc_hd__or3_2_8/A sky130_fd_sc_hd__and4_2_3/A VPWR VGND VPWR VGND sky130_fd_sc_hd__and2b_2
Xsky130_fd_sc_hd__a21oi_2_3 sky130_fd_sc_hd__or4_2_0/B sky130_fd_sc_hd__or3_2_4/X sky130_fd_sc_hd__nand2_2_3/Y sky130_fd_sc_hd__or3_2_7/C VGND VPWR VPWR VGND sky130_fd_sc_hd__a21oi_2
Xsky130_fd_sc_hd__and4_2_4 sky130_fd_sc_hd__and4_2_4/X sky130_fd_sc_hd__inv_2_10/A sky130_fd_sc_hd__nor3_2_2/B sky130_fd_sc_hd__and4_2_4/B sky130_fd_sc_hd__and4_2_4/D VGND VPWR VPWR VGND sky130_fd_sc_hd__and4_2
Xsky130_fd_sc_hd__nand2b_2_0 sky130_fd_sc_hd__or2_2_4/B sky130_fd_sc_hd__mux2_1_4/S sky130_fd_sc_hd__and3_2_0/C VGND VPWR VPWR VGND sky130_fd_sc_hd__nand2b_2
Xsky130_fd_sc_hd__o211a_2_3 sky130_fd_sc_hd__nor2_2_20/Y sky130_fd_sc_hd__o211ai_2_0/Y sky130_fd_sc_hd__a21o_2_3/X sky130_fd_sc_hd__xor2_2_5/X sky130_fd_sc_hd__or4b_2_3/A VPWR VGND VPWR VGND sky130_fd_sc_hd__o211a_2
Xsky130_fd_sc_hd__and3_2_25 sky130_fd_sc_hd__o31a_2_9/X O[0] sky130_fd_sc_hd__or2_2_11/B sky130_fd_sc_hd__and3_2_25/C VPWR VGND VPWR VGND sky130_fd_sc_hd__and3_2
Xsky130_fd_sc_hd__and3_2_14 sky130_fd_sc_hd__or4_2_4/A sky130_fd_sc_hd__xor2_2_11/B sky130_fd_sc_hd__or4_2_4/B sky130_fd_sc_hd__inv_2_7/A VPWR VGND VPWR VGND sky130_fd_sc_hd__and3_2
Xsky130_fd_sc_hd__o211ai_2_0 sky130_fd_sc_hd__or2_2_5/A sky130_fd_sc_hd__mux2_1_2/X sky130_fd_sc_hd__a211o_2_1/X sky130_fd_sc_hd__o211ai_2_0/Y sky130_fd_sc_hd__xor2_2_5/X VGND VPWR VPWR VGND sky130_fd_sc_hd__o211ai_2
Xsky130_fd_sc_hd__or2_2_11 sky130_fd_sc_hd__or2_2_11/B sky130_fd_sc_hd__or2_2_11/X sky130_fd_sc_hd__or2_2_11/A VPWR VGND VPWR VGND sky130_fd_sc_hd__or2_2
Xsky130_fd_sc_hd__xnor2_2_18 sky130_fd_sc_hd__xnor2_2_18/Y sky130_fd_sc_hd__or3_2_9/X sky130_fd_sc_hd__xor2_2_15/X VGND VPWR VPWR VGND sky130_fd_sc_hd__xnor2_2
Xsky130_fd_sc_hd__clkbuf_8_6 sky130_fd_sc_hd__clkbuf_8_6/X sky130_fd_sc_hd__clkbuf_8_9/A VGND VPWR VPWR VGND sky130_fd_sc_hd__clkbuf_8
Xsky130_fd_sc_hd__dfrtp_2_60 sky130_fd_sc_hd__nand4_2_7/C rst_n sky130_fd_sc_hd__o21a_2_19/X sky130_fd_sc_hd__clkbuf_8_8/X VGND VPWR VPWR VGND sky130_fd_sc_hd__dfrtp_2
Xsky130_fd_sc_hd__dfrtp_2_82 sky130_fd_sc_hd__a32o_2_3/B1 rst_n sky130_fd_sc_hd__a32o_2_3/X sky130_fd_sc_hd__dfxtp_2_2/CLK VGND VPWR VPWR VGND sky130_fd_sc_hd__dfrtp_2
Xsky130_fd_sc_hd__dfrtp_2_71 sky130_fd_sc_hd__nand4_2_8/C rst_n sky130_fd_sc_hd__o21a_2_23/X sky130_fd_sc_hd__clkbuf_8_9/X VGND VPWR VPWR VGND sky130_fd_sc_hd__dfrtp_2
Xsky130_fd_sc_hd__mux2_1_9 sky130_fd_sc_hd__inv_2_7/A sky130_fd_sc_hd__mux2_1_9/A1 sky130_fd_sc_hd__mux2_1_9/A0 sky130_fd_sc_hd__mux2_1_9/X VGND VPWR VPWR VGND sky130_fd_sc_hd__mux2_1
Xsky130_fd_sc_hd__or4_2_0 sky130_fd_sc_hd__or4_2_0/C sky130_fd_sc_hd__or4_2_0/A sky130_fd_sc_hd__or4_2_0/X sky130_fd_sc_hd__or4_2_0/B sky130_fd_sc_hd__or4_2_0/D VPWR VGND VPWR VGND sky130_fd_sc_hd__or4_2
Xsky130_fd_sc_hd__or4b_2_3 sky130_fd_sc_hd__or4b_2_3/C sky130_fd_sc_hd__or4b_2_3/A sky130_fd_sc_hd__or4_2_5/C sky130_fd_sc_hd__or4b_2_3/B sky130_fd_sc_hd__or4b_2_2/C VPWR VGND VPWR VGND sky130_fd_sc_hd__or4b_2
Xsky130_fd_sc_hd__xor2_2_11 sky130_fd_sc_hd__xor2_2_11/X sky130_fd_sc_hd__xor2_2_11/B sky130_fd_sc_hd__or4_2_4/C VPWR VGND VPWR VGND sky130_fd_sc_hd__xor2_2
Xsky130_fd_sc_hd__and2b_2_9 sky130_fd_sc_hd__and2b_2_9/X sky130_fd_sc_hd__and2b_2_9/B sky130_fd_sc_hd__and4_2_4/X VPWR VGND VPWR VGND sky130_fd_sc_hd__and2b_2
Xsky130_fd_sc_hd__clkbuf_4_0 sky130_fd_sc_hd__clkbuf_4_0/X sky130_fd_sc_hd__clkbuf_8_1/X VGND VPWR VPWR VGND sky130_fd_sc_hd__clkbuf_4
Xsky130_fd_sc_hd__a21oi_2_4 sky130_fd_sc_hd__or3_2_5/X sky130_fd_sc_hd__and3_2_4/B sky130_fd_sc_hd__and3_2_4/A sky130_fd_sc_hd__nor2_2_21/A VGND VPWR VPWR VGND sky130_fd_sc_hd__a21oi_2
Xsky130_fd_sc_hd__and4_2_5 sky130_fd_sc_hd__and4_2_5/X sky130_fd_sc_hd__and4_2_5/C sky130_fd_sc_hd__and4_2_5/A sky130_fd_sc_hd__and4_2_5/B sky130_fd_sc_hd__and4_2_5/D VGND VPWR VPWR VGND sky130_fd_sc_hd__and4_2
Xsky130_fd_sc_hd__nand2b_2_1 sky130_fd_sc_hd__o21a_2_4/A2 sky130_fd_sc_hd__nand2b_2_1/Y sky130_fd_sc_hd__o21a_2_4/A1 VGND VPWR VPWR VGND sky130_fd_sc_hd__nand2b_2
Xsky130_fd_sc_hd__o211a_2_4 sky130_fd_sc_hd__nor2_2_20/Y sky130_fd_sc_hd__a221o_2_0/X sky130_fd_sc_hd__o21ai_2_1/Y sky130_fd_sc_hd__xor2_2_5/X sky130_fd_sc_hd__or4b_2_3/C VPWR VGND VPWR VGND sky130_fd_sc_hd__o211a_2
Xsky130_fd_sc_hd__and3_2_15 sky130_fd_sc_hd__or2_2_9/A sky130_fd_sc_hd__o31a_2_2/A1 sky130_fd_sc_hd__or3b_2_0/A sky130_fd_sc_hd__or2_2_9/B VPWR VGND VPWR VGND sky130_fd_sc_hd__and3_2
Xsky130_fd_sc_hd__or2_2_12 sky130_fd_sc_hd__or2_2_12/B sky130_fd_sc_hd__or2_2_12/X sky130_fd_sc_hd__or2_2_12/A VPWR VGND VPWR VGND sky130_fd_sc_hd__or2_2
Xsky130_fd_sc_hd__xnor2_2_19 sky130_fd_sc_hd__xnor2_2_19/Y sky130_fd_sc_hd__xnor2_2_21/B sky130_fd_sc_hd__xor2_2_19/X VGND VPWR VPWR VGND sky130_fd_sc_hd__xnor2_2
Xsky130_fd_sc_hd__clkbuf_8_7 sky130_fd_sc_hd__clkbuf_8_7/X sky130_fd_sc_hd__clkbuf_8_9/A VGND VPWR VPWR VGND sky130_fd_sc_hd__clkbuf_8
Xsky130_fd_sc_hd__dfrtp_2_61 sky130_fd_sc_hd__or4_2_9/A rst_n sky130_fd_sc_hd__a21o_2_18/X sky130_fd_sc_hd__dfxtp_2_3/CLK VGND VPWR VPWR VGND sky130_fd_sc_hd__dfrtp_2
Xsky130_fd_sc_hd__dfrtp_2_50 sky130_fd_sc_hd__xor2_2_19/A rst_n sky130_fd_sc_hd__o22a_2_3/X sky130_fd_sc_hd__clkbuf_8_7/X VGND VPWR VPWR VGND sky130_fd_sc_hd__dfrtp_2
Xsky130_fd_sc_hd__dfrtp_2_83 sky130_fd_sc_hd__or2_2_11/B rst_n sky130_fd_sc_hd__or2_2_11/X sky130_fd_sc_hd__dfxtp_2_2/CLK VGND VPWR VPWR VGND sky130_fd_sc_hd__dfrtp_2
Xsky130_fd_sc_hd__dfrtp_2_72 sky130_fd_sc_hd__inv_2_20/A rst_n sky130_fd_sc_hd__o21a_2_26/X sky130_fd_sc_hd__clkbuf_8_11/X VGND VPWR VPWR VGND sky130_fd_sc_hd__dfrtp_2
Xsky130_fd_sc_hd__inv_2_20 sky130_fd_sc_hd__inv_2_20/A sky130_fd_sc_hd__or4_2_6/B VPWR VGND VPWR VGND sky130_fd_sc_hd__inv_2
Xsky130_fd_sc_hd__or4_2_1 sky130_fd_sc_hd__or4_2_1/C sky130_fd_sc_hd__or4_2_1/A sky130_fd_sc_hd__or4_2_1/X sky130_fd_sc_hd__or4_2_1/B sky130_fd_sc_hd__or4_2_1/D VPWR VGND VPWR VGND sky130_fd_sc_hd__or4_2
Xsky130_fd_sc_hd__or4b_2_4 sky130_fd_sc_hd__or4_2_4/C sky130_fd_sc_hd__or4_2_4/B sky130_fd_sc_hd__or4_2_9/C sky130_fd_sc_hd__or4_2_4/D sky130_fd_sc_hd__or4_2_4/A VPWR VGND VPWR VGND sky130_fd_sc_hd__or4b_2
Xsky130_fd_sc_hd__xor2_2_12 sky130_fd_sc_hd__xor2_2_12/X sky130_fd_sc_hd__o31a_2_1/X sky130_fd_sc_hd__xor2_2_14/B VPWR VGND VPWR VGND sky130_fd_sc_hd__xor2_2
Xsky130_fd_sc_hd__clkbuf_4_1 sky130_fd_sc_hd__clkbuf_4_1/X sky130_fd_sc_hd__clkbuf_8_0/X VGND VPWR VPWR VGND sky130_fd_sc_hd__clkbuf_4
Xsky130_fd_sc_hd__a21oi_2_5 sky130_fd_sc_hd__xor2_2_9/A sky130_fd_sc_hd__xor2_2_4/A sky130_fd_sc_hd__xor2_2_0/B sky130_fd_sc_hd__a21oi_2_5/Y VGND VPWR VPWR VGND sky130_fd_sc_hd__a21oi_2
Xsky130_fd_sc_hd__and4_2_6 sky130_fd_sc_hd__and4_2_6/X sky130_fd_sc_hd__and4_2_6/C sky130_fd_sc_hd__and4_2_6/A sky130_fd_sc_hd__and4_2_6/B sky130_fd_sc_hd__and4_2_6/D VGND VPWR VPWR VGND sky130_fd_sc_hd__and4_2
Xsky130_fd_sc_hd__nand2b_2_2 sky130_fd_sc_hd__nand4_2_1/Y sky130_fd_sc_hd__nand2b_2_2/Y sky130_fd_sc_hd__and2b_2_3/B VGND VPWR VPWR VGND sky130_fd_sc_hd__nand2b_2
Xsky130_fd_sc_hd__o211a_2_5 sky130_fd_sc_hd__nor2_2_20/Y sky130_fd_sc_hd__a211o_2_0/X sky130_fd_sc_hd__mux2_1_3/X sky130_fd_sc_hd__xor2_2_5/X sky130_fd_sc_hd__or4b_2_2/C VPWR VGND VPWR VGND sky130_fd_sc_hd__o211a_2
Xsky130_fd_sc_hd__a221oi_2_0 sky130_fd_sc_hd__or4_2_4/D sky130_fd_sc_hd__a41oi_2_0/Y sky130_fd_sc_hd__inv_2_9/A sky130_fd_sc_hd__inv_2_7/A sky130_fd_sc_hd__and4_2_7/X sky130_fd_sc_hd__dfrtp_2_45/D VGND VPWR VPWR VGND sky130_fd_sc_hd__a221oi_2
Xsky130_fd_sc_hd__and3_2_16 sky130_fd_sc_hd__or2_2_9/A sky130_fd_sc_hd__and3_2_16/X sky130_fd_sc_hd__or3b_2_0/A sky130_fd_sc_hd__or2_2_9/B VPWR VGND VPWR VGND sky130_fd_sc_hd__and3_2
Xsky130_fd_sc_hd__clkbuf_8_8 sky130_fd_sc_hd__clkbuf_8_8/X sky130_fd_sc_hd__clkbuf_8_9/A VGND VPWR VPWR VGND sky130_fd_sc_hd__clkbuf_8
Xsky130_fd_sc_hd__dfrtp_2_51 sky130_fd_sc_hd__xor2_2_19/B rst_n sky130_fd_sc_hd__a221o_2_2/X sky130_fd_sc_hd__clkbuf_8_7/X VGND VPWR VPWR VGND sky130_fd_sc_hd__dfrtp_2
Xsky130_fd_sc_hd__dfrtp_2_40 sky130_fd_sc_hd__mux2_1_9/A0 rst_n sky130_fd_sc_hd__mux2_1_9/X sky130_fd_sc_hd__clkbuf_8_5/X VGND VPWR VPWR VGND sky130_fd_sc_hd__dfrtp_2
Xsky130_fd_sc_hd__dfrtp_2_73 sky130_fd_sc_hd__nand4_2_13/C rst_n sky130_fd_sc_hd__o21a_2_25/X sky130_fd_sc_hd__clkbuf_8_11/X VGND VPWR VPWR VGND sky130_fd_sc_hd__dfrtp_2
Xsky130_fd_sc_hd__dfrtp_2_62 sky130_fd_sc_hd__inv_2_18/A rst_n sky130_fd_sc_hd__o21a_2_20/X sky130_fd_sc_hd__dfxtp_2_3/CLK VGND VPWR VPWR VGND sky130_fd_sc_hd__dfrtp_2
Xsky130_fd_sc_hd__inv_2_21 sky130_fd_sc_hd__or2_2_8/B sky130_fd_sc_hd__inv_2_21/Y VPWR VGND VPWR VGND sky130_fd_sc_hd__inv_2
Xsky130_fd_sc_hd__inv_2_10 sky130_fd_sc_hd__inv_2_10/A sky130_fd_sc_hd__inv_2_10/Y VPWR VGND VPWR VGND sky130_fd_sc_hd__inv_2
Xsky130_fd_sc_hd__nand2_2_0 sky130_fd_sc_hd__and3_2_1/C sky130_fd_sc_hd__or2_2_1/X sky130_fd_sc_hd__or3_2_0/B VGND VPWR VPWR VGND sky130_fd_sc_hd__nand2_2
Xsky130_fd_sc_hd__or4_2_2 sky130_fd_sc_hd__or4_2_2/C sky130_fd_sc_hd__or4_2_2/A sky130_fd_sc_hd__or4_2_2/X sky130_fd_sc_hd__or4_2_2/B sky130_fd_sc_hd__or4_2_2/D VPWR VGND VPWR VGND sky130_fd_sc_hd__or4_2
Xsky130_fd_sc_hd__or4b_2_5 sky130_fd_sc_hd__or4_2_4/D sky130_fd_sc_hd__or4_2_4/B sky130_fd_sc_hd__or4_2_8/C sky130_fd_sc_hd__or4_2_4/A sky130_fd_sc_hd__or4_2_4/C VPWR VGND VPWR VGND sky130_fd_sc_hd__or4b_2
Xsky130_fd_sc_hd__xor2_2_13 sky130_fd_sc_hd__xor2_2_13/X sky130_fd_sc_hd__xor2_2_19/B sky130_fd_sc_hd__or2_2_12/A VPWR VGND VPWR VGND sky130_fd_sc_hd__xor2_2
Xsky130_fd_sc_hd__and4bb_2_10 sky130_fd_sc_hd__or4_2_4/D sky130_fd_sc_hd__or4_2_4/A sky130_fd_sc_hd__or4_2_4/C sky130_fd_sc_hd__nand4_2_8/D sky130_fd_sc_hd__or4_2_4/B VGND VPWR VPWR VGND sky130_fd_sc_hd__and4bb_2
Xsky130_fd_sc_hd__clkbuf_4_2 sky130_fd_sc_hd__clkbuf_4_2/X sky130_fd_sc_hd__clkbuf_8_4/X VGND VPWR VPWR VGND sky130_fd_sc_hd__clkbuf_4
Xsky130_fd_sc_hd__a21oi_2_6 sky130_fd_sc_hd__or3_2_5/B sky130_fd_sc_hd__xnor2_2_4/A sky130_fd_sc_hd__xor2_2_4/A sky130_fd_sc_hd__a21oi_2_6/Y VGND VPWR VPWR VGND sky130_fd_sc_hd__a21oi_2
Xsky130_fd_sc_hd__and4_2_7 sky130_fd_sc_hd__and4_2_7/X sky130_fd_sc_hd__or4_2_4/C sky130_fd_sc_hd__or4_2_4/B sky130_fd_sc_hd__or4_2_4/A sky130_fd_sc_hd__inv_2_7/A VGND VPWR VPWR VGND sky130_fd_sc_hd__and4_2
Xsky130_fd_sc_hd__nand2b_2_3 sky130_fd_sc_hd__o21a_2_8/A2 sky130_fd_sc_hd__nand2b_2_3/Y sky130_fd_sc_hd__o21a_2_8/A1 VGND VPWR sky130_fd_sc_hd__dfrtp_2_5/VPB VGND sky130_fd_sc_hd__nand2b_2
Xsky130_fd_sc_hd__o211a_2_6 sky130_fd_sc_hd__or3_2_1/X sky130_fd_sc_hd__or4_2_0/B sky130_fd_sc_hd__or3_2_4/B sky130_fd_sc_hd__nand2_2_3/Y sky130_fd_sc_hd__or3_2_7/B VPWR VGND VPWR VGND sky130_fd_sc_hd__o211a_2
Xsky130_fd_sc_hd__and3_2_17 sky130_fd_sc_hd__inv_2_14/Y sky130_fd_sc_hd__and3_2_17/X sky130_fd_sc_hd__or3b_2_0/A sky130_fd_sc_hd__and3_2_17/C VPWR VGND VPWR VGND sky130_fd_sc_hd__and3_2
Xsky130_fd_sc_hd__a21bo_2_0 sky130_fd_sc_hd__a32o_2_1/B2 sky130_fd_sc_hd__or2_2_3/X sky130_fd_sc_hd__a31o_2_5/A2 sky130_fd_sc_hd__or3_2_0/B VGND VPWR VPWR VGND sky130_fd_sc_hd__a21bo_2
Xsky130_fd_sc_hd__a31oi_2_0 sky130_fd_sc_hd__nand2b_2_8/Y sky130_fd_sc_hd__and3b_2_0/C sky130_fd_sc_hd__o31a_2_0/A2 sky130_fd_sc_hd__nor3_2_1/C sky130_fd_sc_hd__o32ai_2_0/B1 VPWR VGND VPWR VGND sky130_fd_sc_hd__a31oi_2
Xsky130_fd_sc_hd__o311a_2_0 sky130_fd_sc_hd__o311a_2_0/X sky130_fd_sc_hd__or4_2_0/A sky130_fd_sc_hd__and3_2_0/X sky130_fd_sc_hd__nor2_2_26/Y sky130_fd_sc_hd__or4_2_0/B sky130_fd_sc_hd__o311a_2_0/C1 VPWR VGND VPWR VGND sky130_fd_sc_hd__o311a_2
Xsky130_fd_sc_hd__a21oi_2_10 sky130_fd_sc_hd__nor2_2_6/Y sky130_fd_sc_hd__xor2_2_7/X sky130_fd_sc_hd__xor2_2_0/B sky130_fd_sc_hd__xor2_2_1/B VGND VPWR VPWR VGND sky130_fd_sc_hd__a21oi_2
Xsky130_fd_sc_hd__clkbuf_8_9 sky130_fd_sc_hd__clkbuf_8_9/X sky130_fd_sc_hd__clkbuf_8_9/A VGND VPWR VPWR VGND sky130_fd_sc_hd__clkbuf_8
Xsky130_fd_sc_hd__dfrtp_2_52 sky130_fd_sc_hd__or4_2_5/A rst_n sky130_fd_sc_hd__a21o_2_13/X sky130_fd_sc_hd__clkbuf_4_9/A VGND VPWR VPWR VGND sky130_fd_sc_hd__dfrtp_2
Xsky130_fd_sc_hd__dfrtp_2_30 sky130_fd_sc_hd__mux2_1_8/A1 rst_n sky130_fd_sc_hd__mux2_1_14/X sky130_fd_sc_hd__clkbuf_8_2/X VGND VPWR VPWR VGND sky130_fd_sc_hd__dfrtp_2
Xsky130_fd_sc_hd__dfrtp_2_41 sky130_fd_sc_hd__a22o_2_2/A2 rst_n sky130_fd_sc_hd__mux2_1_13/X sky130_fd_sc_hd__clkbuf_8_8/X VGND VPWR VPWR VGND sky130_fd_sc_hd__dfrtp_2
Xsky130_fd_sc_hd__dfrtp_2_74 sky130_fd_sc_hd__nand4_2_12/C rst_n sky130_fd_sc_hd__o21a_2_27/X sky130_fd_sc_hd__clkbuf_8_11/X VGND VPWR VPWR VGND sky130_fd_sc_hd__dfrtp_2
Xsky130_fd_sc_hd__dfrtp_2_63 sky130_fd_sc_hd__o21a_2_23/A1 rst_n sky130_fd_sc_hd__dfrtp_2_63/D sky130_fd_sc_hd__clkbuf_8_9/X VGND VPWR VPWR VGND sky130_fd_sc_hd__dfrtp_2
Xsky130_fd_sc_hd__inv_2_11 sky130_fd_sc_hd__inv_2_11/A sky130_fd_sc_hd__inv_2_23/A VPWR VGND VPWR VGND sky130_fd_sc_hd__inv_2
Xsky130_fd_sc_hd__inv_2_22 success sky130_fd_sc_hd__inv_2_22/Y VPWR VGND VPWR VGND sky130_fd_sc_hd__inv_2
Xsky130_fd_sc_hd__nand2_2_1 sky130_fd_sc_hd__and2_2_2/A sky130_fd_sc_hd__xor2_2_3/A sky130_fd_sc_hd__or2_2_0/B VGND VPWR VPWR VGND sky130_fd_sc_hd__nand2_2
Xsky130_fd_sc_hd__or4_2_3 sky130_fd_sc_hd__or4_2_3/C sky130_fd_sc_hd__or4_2_3/A sky130_fd_sc_hd__or4_2_3/X sky130_fd_sc_hd__or4_2_3/B sky130_fd_sc_hd__or4_2_3/D VPWR VGND VPWR VGND sky130_fd_sc_hd__or4_2
Xsky130_fd_sc_hd__o32a_2_0 sky130_fd_sc_hd__o32a_2_1/B2 sky130_fd_sc_hd__nor2_2_3/Y sky130_fd_sc_hd__o32a_2_0/A3 sky130_fd_sc_hd__and3_2_0/X sky130_fd_sc_hd__or4_2_0/A sky130_fd_sc_hd__o32a_2_0/X VGND VPWR VPWR VGND sky130_fd_sc_hd__o32a_2
Xsky130_fd_sc_hd__or4b_2_6 sky130_fd_sc_hd__or4_2_4/C sky130_fd_sc_hd__or4_2_4/A sky130_fd_sc_hd__or4_2_7/C sky130_fd_sc_hd__or4_2_4/D sky130_fd_sc_hd__or4_2_4/B VPWR VGND VPWR VGND sky130_fd_sc_hd__or4b_2
Xsky130_fd_sc_hd__xor2_2_14 sky130_fd_sc_hd__xor2_2_14/X sky130_fd_sc_hd__xor2_2_14/B sky130_fd_sc_hd__xor2_2_16/A VPWR VGND VPWR VGND sky130_fd_sc_hd__xor2_2
Xsky130_fd_sc_hd__and4bb_2_11 sky130_fd_sc_hd__or4_2_4/B sky130_fd_sc_hd__or4_2_4/D sky130_fd_sc_hd__or4_2_4/C sky130_fd_sc_hd__nand4_2_12/D sky130_fd_sc_hd__or4_2_4/A VGND VPWR VPWR VGND sky130_fd_sc_hd__and4bb_2
Xsky130_fd_sc_hd__clkbuf_4_3 sky130_fd_sc_hd__clkbuf_4_3/X sky130_fd_sc_hd__clkbuf_8_3/X VGND VPWR VPWR VGND sky130_fd_sc_hd__clkbuf_4
Xsky130_fd_sc_hd__a21oi_2_7 sky130_fd_sc_hd__and4bb_2_0/X sky130_fd_sc_hd__o22ai_2_0/Y sky130_fd_sc_hd__xor2_2_6/A sky130_fd_sc_hd__xor2_2_5/A VGND VPWR VPWR VGND sky130_fd_sc_hd__a21oi_2
Xsky130_fd_sc_hd__nand2b_2_4 sky130_fd_sc_hd__nand4_2_5/Y sky130_fd_sc_hd__nand2b_2_4/Y sky130_fd_sc_hd__o21a_2_30/A1 VGND VPWR VPWR VGND sky130_fd_sc_hd__nand2b_2
Xsky130_fd_sc_hd__o211a_2_7 sky130_fd_sc_hd__inv_2_5/Y sky130_fd_sc_hd__a31o_2_8/X sky130_fd_sc_hd__mux2_1_5/A1 sky130_fd_sc_hd__and3_2_7/C sky130_fd_sc_hd__o211a_2_7/X VPWR VGND VPWR VGND sky130_fd_sc_hd__o211a_2
Xsky130_fd_sc_hd__and3_2_18 sky130_fd_sc_hd__o31a_2_6/X O[1] sky130_fd_sc_hd__or2_2_11/B sky130_fd_sc_hd__and3_2_25/C VPWR VGND VPWR VGND sky130_fd_sc_hd__and3_2
Xsky130_fd_sc_hd__a21bo_2_1 sky130_fd_sc_hd__a211o_2_2/X sky130_fd_sc_hd__nor2_2_5/Y sky130_fd_sc_hd__a21o_2_3/A2 sky130_fd_sc_hd__or4_2_0/A VGND VPWR VPWR VGND sky130_fd_sc_hd__a21bo_2
Xsky130_fd_sc_hd__o311a_2_1 sky130_fd_sc_hd__o311a_2_1/X sky130_fd_sc_hd__and3_2_7/C sky130_fd_sc_hd__mux2_1_5/A1 sky130_fd_sc_hd__xor2_2_7/A sky130_fd_sc_hd__nand3_2_0/Y sky130_fd_sc_hd__a21o_2_9/X VPWR VGND VPWR VGND sky130_fd_sc_hd__o311a_2
Xsky130_fd_sc_hd__a21oi_2_11 sky130_fd_sc_hd__or3_2_8/A sky130_fd_sc_hd__inv_2_7/A I sky130_fd_sc_hd__nor2_2_30/B VGND VPWR VPWR VGND sky130_fd_sc_hd__a21oi_2
Xsky130_fd_sc_hd__dfrtp_2_20 sky130_fd_sc_hd__and4_2_3/C rst_n sky130_fd_sc_hd__xnor2_2_11/Y sky130_fd_sc_hd__clkbuf_8_3/X VGND VPWR VPWR VGND sky130_fd_sc_hd__dfrtp_2
Xsky130_fd_sc_hd__dfrtp_2_42 sky130_fd_sc_hd__mux2_1_15/A0 rst_n sky130_fd_sc_hd__mux2_1_15/X sky130_fd_sc_hd__clkbuf_8_6/X VGND VPWR VPWR VGND sky130_fd_sc_hd__dfrtp_2
Xsky130_fd_sc_hd__dfrtp_2_31 sky130_fd_sc_hd__mux2_1_19/A1 rst_n sky130_fd_sc_hd__mux2_1_18/X sky130_fd_sc_hd__clkbuf_8_5/X VGND VPWR VPWR VGND sky130_fd_sc_hd__dfrtp_2
Xsky130_fd_sc_hd__dfrtp_2_75 sky130_fd_sc_hd__nand4_2_11/C rst_n sky130_fd_sc_hd__o21a_2_24/X sky130_fd_sc_hd__clkbuf_8_10/X VGND VPWR VPWR VGND sky130_fd_sc_hd__dfrtp_2
Xsky130_fd_sc_hd__dfrtp_2_64 sky130_fd_sc_hd__o21a_2_28/A1 rst_n sky130_fd_sc_hd__dfrtp_2_64/D sky130_fd_sc_hd__clkbuf_8_11/X VGND VPWR VPWR VGND sky130_fd_sc_hd__dfrtp_2
Xsky130_fd_sc_hd__dfrtp_2_53 sky130_fd_sc_hd__nand4_2_5/C rst_n sky130_fd_sc_hd__o21a_2_30/X sky130_fd_sc_hd__clkbuf_8_2/X VGND VPWR sky130_fd_sc_hd__nand4_2_5/VPB VGND sky130_fd_sc_hd__dfrtp_2
Xsky130_fd_sc_hd__inv_2_12 sky130_fd_sc_hd__inv_2_12/A sky130_fd_sc_hd__inv_2_12/Y VPWR VGND VPWR VGND sky130_fd_sc_hd__inv_2
Xsky130_fd_sc_hd__inv_2_23 sky130_fd_sc_hd__inv_2_23/A sky130_fd_sc_hd__inv_2_23/Y VPWR VGND VPWR VGND sky130_fd_sc_hd__inv_2
Xsky130_fd_sc_hd__nand2_2_2 sky130_fd_sc_hd__nand2_2_2/Y sky130_fd_sc_hd__xor2_2_7/A sky130_fd_sc_hd__xor2_2_0/B VGND VPWR VPWR VGND sky130_fd_sc_hd__nand2_2
Xsky130_fd_sc_hd__or4_2_4 sky130_fd_sc_hd__or4_2_4/C sky130_fd_sc_hd__or4_2_4/A sky130_fd_sc_hd__or4_2_4/X sky130_fd_sc_hd__or4_2_4/B sky130_fd_sc_hd__or4_2_4/D VPWR VGND VPWR VGND sky130_fd_sc_hd__or4_2
Xsky130_fd_sc_hd__o32a_2_1 sky130_fd_sc_hd__o32a_2_1/B1 sky130_fd_sc_hd__o32a_2_1/B2 sky130_fd_sc_hd__o32a_2_1/A3 sky130_fd_sc_hd__and3_2_0/X sky130_fd_sc_hd__or4_2_0/A sky130_fd_sc_hd__o32a_2_1/X VGND VPWR VPWR VGND sky130_fd_sc_hd__o32a_2
Xsky130_fd_sc_hd__or4b_2_7 sky130_fd_sc_hd__or4_2_4/C sky130_fd_sc_hd__or4_2_4/B sky130_fd_sc_hd__or4_2_6/C sky130_fd_sc_hd__or4_2_4/A sky130_fd_sc_hd__or4_2_4/D VPWR VGND VPWR VGND sky130_fd_sc_hd__or4b_2
Xsky130_fd_sc_hd__xor2_2_15 sky130_fd_sc_hd__xor2_2_15/X sky130_fd_sc_hd__or2_2_9/X sky130_fd_sc_hd__xor2_2_19/B VPWR VGND VPWR VGND sky130_fd_sc_hd__xor2_2
Xsky130_fd_sc_hd__a21boi_2_0 sky130_fd_sc_hd__inv_2_7/A sky130_fd_sc_hd__nor2_2_40/A I sky130_fd_sc_hd__o21ai_2_3/B1 VPWR VGND sky130_fd_sc_hd__nor2_2_34/VPB VGND sky130_fd_sc_hd__a21boi_2
Xsky130_fd_sc_hd__and4bb_2_12 sky130_fd_sc_hd__or4_2_4/A sky130_fd_sc_hd__or4_2_4/D sky130_fd_sc_hd__or4_2_4/C sky130_fd_sc_hd__nand4_2_13/D sky130_fd_sc_hd__or4_2_4/B VGND VPWR VPWR VGND sky130_fd_sc_hd__and4bb_2
Xsky130_fd_sc_hd__clkbuf_4_4 sky130_fd_sc_hd__clkbuf_4_4/X sky130_fd_sc_hd__clkbuf_8_2/X VGND VPWR VPWR VGND sky130_fd_sc_hd__clkbuf_4
Xsky130_fd_sc_hd__a21oi_2_8 sky130_fd_sc_hd__or2_2_8/B sky130_fd_sc_hd__or2_2_9/A sky130_fd_sc_hd__or3b_2_0/A sky130_fd_sc_hd__and3b_2_0/C VGND VPWR VPWR VGND sky130_fd_sc_hd__a21oi_2
Xsky130_fd_sc_hd__nand2b_2_5 sky130_fd_sc_hd__o21a_2_5/A2 sky130_fd_sc_hd__dfrtp_2_4/D sky130_fd_sc_hd__o21a_2_5/A1 VGND VPWR VPWR VGND sky130_fd_sc_hd__nand2b_2
Xsky130_fd_sc_hd__o211a_2_8 sky130_fd_sc_hd__inv_2_7/A sky130_fd_sc_hd__or2_2_7/X sky130_fd_sc_hd__mux2_1_7/A0 sky130_fd_sc_hd__inv_2_8/A sky130_fd_sc_hd__o211a_2_8/X VPWR VGND VPWR VGND sky130_fd_sc_hd__o211a_2
Xsky130_fd_sc_hd__and3_2_19 sky130_fd_sc_hd__o31a_2_4/X O[6] sky130_fd_sc_hd__or2_2_11/B sky130_fd_sc_hd__and3_2_25/C VPWR VGND VPWR VGND sky130_fd_sc_hd__and3_2
Xsky130_fd_sc_hd__o22a_2_0 sky130_fd_sc_hd__mux2_1_4/S sky130_fd_sc_hd__o22a_2_0/X sky130_fd_sc_hd__or2_2_4/X sky130_fd_sc_hd__or3_2_3/B sky130_fd_sc_hd__nor2_2_4/Y VGND VPWR VPWR VGND sky130_fd_sc_hd__o22a_2
Xsky130_fd_sc_hd__and2b_2_20 sky130_fd_sc_hd__and4_2_1/C sky130_fd_sc_hd__o21a_2_30/A1 sky130_fd_sc_hd__nand4_2_5/C VPWR VGND sky130_fd_sc_hd__nand4_2_5/VPB VGND sky130_fd_sc_hd__and2b_2
Xsky130_fd_sc_hd__a21oi_2_12 sky130_fd_sc_hd__mux2_1_6/X sky130_fd_sc_hd__mux2_1_7/A0 sky130_fd_sc_hd__inv_2_8/Y sky130_fd_sc_hd__dfrtp_2_29/D VGND VPWR VPWR VGND sky130_fd_sc_hd__a21oi_2
Xsky130_fd_sc_hd__dfrtp_2_10 sky130_fd_sc_hd__o21a_2_30/A1 rst_n sky130_fd_sc_hd__nand2b_2_4/Y sky130_fd_sc_hd__clkbuf_8_2/X VGND VPWR VPWR VGND sky130_fd_sc_hd__dfrtp_2
Xsky130_fd_sc_hd__dfrtp_2_21 sky130_fd_sc_hd__nor3_2_2/A rst_n sky130_fd_sc_hd__o21a_2_12/X sky130_fd_sc_hd__clkbuf_8_3/X VGND VPWR VPWR VGND sky130_fd_sc_hd__dfrtp_2
Xsky130_fd_sc_hd__dfrtp_2_43 sky130_fd_sc_hd__or4_2_4/B rst_n sky130_fd_sc_hd__dfrtp_2_43/D sky130_fd_sc_hd__clkbuf_8_5/X VGND VPWR VPWR VGND sky130_fd_sc_hd__dfrtp_2
Xsky130_fd_sc_hd__dfrtp_2_32 sky130_fd_sc_hd__mux2_1_9/A1 rst_n sky130_fd_sc_hd__mux2_1_17/X sky130_fd_sc_hd__clkbuf_8_6/X VGND VPWR VPWR VGND sky130_fd_sc_hd__dfrtp_2
Xsky130_fd_sc_hd__dfrtp_2_65 sky130_fd_sc_hd__inv_2_19/A rst_n sky130_fd_sc_hd__o21a_2_22/X sky130_fd_sc_hd__clkbuf_8_9/X VGND VPWR VPWR VGND sky130_fd_sc_hd__dfrtp_2
Xsky130_fd_sc_hd__dfrtp_2_76 sky130_fd_sc_hd__inv_2_17/A rst_n sky130_fd_sc_hd__o21a_2_29/X sky130_fd_sc_hd__dfxtp_2_3/CLK VGND VPWR VPWR VGND sky130_fd_sc_hd__dfrtp_2
Xsky130_fd_sc_hd__dfrtp_2_54 sky130_fd_sc_hd__inv_2_16/A rst_n sky130_fd_sc_hd__o21a_2_17/X sky130_fd_sc_hd__clkbuf_4_9/A VGND VPWR VPWR VGND sky130_fd_sc_hd__dfrtp_2
Xsky130_fd_sc_hd__inv_2_24 sky130_fd_sc_hd__or4b_2_8/X sky130_fd_sc_hd__nor3_2_3/C VPWR VGND VPWR VGND sky130_fd_sc_hd__inv_2
Xsky130_fd_sc_hd__inv_2_13 sky130_fd_sc_hd__or2_2_8/B sky130_fd_sc_hd__inv_2_13/Y VPWR VGND VPWR VGND sky130_fd_sc_hd__inv_2
Xsky130_fd_sc_hd__nand2_2_3 sky130_fd_sc_hd__nand2_2_3/Y sky130_fd_sc_hd__or4_2_0/A sky130_fd_sc_hd__o21a_2_3/A2 VGND VPWR VPWR VGND sky130_fd_sc_hd__nand2_2
Xsky130_fd_sc_hd__or4_2_5 sky130_fd_sc_hd__or4_2_5/C sky130_fd_sc_hd__or4_2_5/A sky130_fd_sc_hd__or4_2_5/X sky130_fd_sc_hd__or4_2_5/B sky130_fd_sc_hd__or4_2_5/D VPWR VGND VPWR VGND sky130_fd_sc_hd__or4_2
Xsky130_fd_sc_hd__and4b_2_0 sky130_fd_sc_hd__or3_2_6/B sky130_fd_sc_hd__or2_2_8/B sky130_fd_sc_hd__or3b_2_0/A sky130_fd_sc_hd__or2_2_9/A sky130_fd_sc_hd__or2_2_9/B VPWR VGND VPWR VGND sky130_fd_sc_hd__and4b_2
Xsky130_fd_sc_hd__nor3_2_0 sky130_fd_sc_hd__or2_2_9/B sky130_fd_sc_hd__nor3_2_0/Y sky130_fd_sc_hd__or3b_2_0/A sky130_fd_sc_hd__or2_2_9/A VGND VPWR VPWR VGND sky130_fd_sc_hd__nor3_2
Xsky130_fd_sc_hd__o32a_2_2 sky130_fd_sc_hd__o32a_2_2/B1 sky130_fd_sc_hd__o32a_2_2/B2 sky130_fd_sc_hd__o32a_2_2/A3 sky130_fd_sc_hd__o32a_2_2/A2 sky130_fd_sc_hd__inv_2_12/Y sky130_fd_sc_hd__o32a_2_2/X VGND VPWR VPWR VGND sky130_fd_sc_hd__o32a_2
Xsky130_fd_sc_hd__or4b_2_8 sky130_fd_sc_hd__or4b_2_8/C sky130_fd_sc_hd__or4b_2_8/A sky130_fd_sc_hd__or4b_2_8/X success sky130_fd_sc_hd__a32o_2_3/B1 VPWR VGND VPWR VGND sky130_fd_sc_hd__or4b_2
Xsky130_fd_sc_hd__xor2_2_16 sky130_fd_sc_hd__xor2_2_16/X sky130_fd_sc_hd__or2_2_12/B sky130_fd_sc_hd__xor2_2_16/A VPWR VGND VPWR VGND sky130_fd_sc_hd__xor2_2
Xsky130_fd_sc_hd__a21boi_2_1 sky130_fd_sc_hd__or2_2_11/B sky130_fd_sc_hd__xnor2_2_28/Y sky130_fd_sc_hd__and3_2_25/C sky130_fd_sc_hd__dfxtp_2_1/D VPWR VGND VPWR VGND sky130_fd_sc_hd__a21boi_2
Xsky130_fd_sc_hd__and4bb_2_13 sky130_fd_sc_hd__or4_2_4/A sky130_fd_sc_hd__or4_2_4/C sky130_fd_sc_hd__or4_2_4/D sky130_fd_sc_hd__nand4_2_10/D sky130_fd_sc_hd__or4_2_4/B VGND VPWR VPWR VGND sky130_fd_sc_hd__and4bb_2
Xsky130_fd_sc_hd__clkbuf_4_5 sky130_fd_sc_hd__clkbuf_4_5/X sky130_fd_sc_hd__clkbuf_8_5/X VGND VPWR VPWR VGND sky130_fd_sc_hd__clkbuf_4
Xsky130_fd_sc_hd__a21oi_2_9 sky130_fd_sc_hd__or2_2_8/B sky130_fd_sc_hd__or2_2_9/A sky130_fd_sc_hd__or3b_2_0/A sky130_fd_sc_hd__or3_2_6/A VGND VPWR VPWR VGND sky130_fd_sc_hd__a21oi_2
Xsky130_fd_sc_hd__nand2b_2_6 sky130_fd_sc_hd__xor2_2_4/X sky130_fd_sc_hd__and3_2_4/A sky130_fd_sc_hd__xnor2_2_4/A VGND VPWR VPWR VGND sky130_fd_sc_hd__nand2b_2
Xsky130_fd_sc_hd__o211a_2_9 sky130_fd_sc_hd__o21ai_2_5/Y sky130_fd_sc_hd__o21a_2_15/A2 sky130_fd_sc_hd__or2_2_8/X sky130_fd_sc_hd__or2_2_9/A sky130_fd_sc_hd__o211a_2_9/X VPWR VGND sky130_fd_sc_hd__or2_2_8/VPB VGND sky130_fd_sc_hd__o211a_2
Xsky130_fd_sc_hd__a221o_2_0 sky130_fd_sc_hd__a221o_2_0/X sky130_fd_sc_hd__or2_2_5/X sky130_fd_sc_hd__or4_2_0/A sky130_fd_sc_hd__a21oi_2_2/Y sky130_fd_sc_hd__o22ai_2_1/Y VGND VPWR sky130_fd_sc_hd__or3_2_7/A VPWR VGND sky130_fd_sc_hd__a221o_2
Xsky130_fd_sc_hd__o22a_2_1 sky130_fd_sc_hd__or2_2_9/B sky130_fd_sc_hd__or3_2_16/A sky130_fd_sc_hd__or3_2_6/A sky130_fd_sc_hd__or2_2_9/A sky130_fd_sc_hd__or3_2_6/B VGND VPWR VPWR VGND sky130_fd_sc_hd__o22a_2
Xsky130_fd_sc_hd__o21a_2_30 sky130_fd_sc_hd__o21a_2_30/A1 sky130_fd_sc_hd__a31o_2_25/X sky130_fd_sc_hd__nand4_2_5/Y sky130_fd_sc_hd__o21a_2_30/X VGND VPWR VPWR VGND sky130_fd_sc_hd__o21a_2
Xsky130_fd_sc_hd__and2b_2_10 sky130_fd_sc_hd__dfrtp_2_25/D sky130_fd_sc_hd__a21o_2_10/X sky130_fd_sc_hd__and3_2_11/X VPWR VGND VPWR VGND sky130_fd_sc_hd__and2b_2
Xsky130_fd_sc_hd__and2b_2_21 sky130_fd_sc_hd__and3_2_5/C sky130_fd_sc_hd__o21a_2_18/A1 sky130_fd_sc_hd__nand4_2_6/C VPWR VGND VPWR VGND sky130_fd_sc_hd__and2b_2
Xsky130_fd_sc_hd__a21oi_2_13 sky130_fd_sc_hd__or4_2_4/B sky130_fd_sc_hd__inv_2_7/A sky130_fd_sc_hd__or4_2_4/A sky130_fd_sc_hd__a21oi_2_13/Y VGND VPWR VPWR VGND sky130_fd_sc_hd__a21oi_2
Xsky130_fd_sc_hd__dfrtp_2_22 sky130_fd_sc_hd__or3_2_8/C rst_n sky130_fd_sc_hd__xor2_2_10/X sky130_fd_sc_hd__dfrtp_2_8/CLK VGND VPWR VPWR VGND sky130_fd_sc_hd__dfrtp_2
Xsky130_fd_sc_hd__dfrtp_2_11 sky130_fd_sc_hd__and2b_2_3/B rst_n sky130_fd_sc_hd__nand2b_2_2/Y sky130_fd_sc_hd__clkbuf_8_1/X VGND VPWR VPWR VGND sky130_fd_sc_hd__dfrtp_2
Xsky130_fd_sc_hd__dfrtp_2_33 sky130_fd_sc_hd__mux2_1_12/A1 rst_n sky130_fd_sc_hd__mux2_1_10/X sky130_fd_sc_hd__clkbuf_8_2/X VGND VPWR VPWR VGND sky130_fd_sc_hd__dfrtp_2
Xsky130_fd_sc_hd__dfrtp_2_66 sky130_fd_sc_hd__o21a_2_21/A1 rst_n sky130_fd_sc_hd__dfrtp_2_66/D sky130_fd_sc_hd__clkbuf_8_10/X VGND VPWR VPWR VGND sky130_fd_sc_hd__dfrtp_2
Xsky130_fd_sc_hd__dfrtp_2_77 sky130_fd_sc_hd__or4_2_7/A rst_n sky130_fd_sc_hd__a21o_2_14/X sky130_fd_sc_hd__clkbuf_8_9/X VGND VPWR VPWR VGND sky130_fd_sc_hd__dfrtp_2
Xsky130_fd_sc_hd__dfrtp_2_44 sky130_fd_sc_hd__or4_2_4/A rst_n sky130_fd_sc_hd__nor2_2_31/Y sky130_fd_sc_hd__clkbuf_8_5/X VGND VPWR VPWR VGND sky130_fd_sc_hd__dfrtp_2
Xsky130_fd_sc_hd__dfrtp_2_55 sky130_fd_sc_hd__nand4_2_6/C rst_n sky130_fd_sc_hd__o21a_2_18/X sky130_fd_sc_hd__clkbuf_8_8/X VGND VPWR VPWR VGND sky130_fd_sc_hd__dfrtp_2
Xsky130_fd_sc_hd__inv_2_14 sky130_fd_sc_hd__or2_2_8/B sky130_fd_sc_hd__inv_2_14/Y VPWR VGND sky130_fd_sc_hd__o31a_2_2/VPB VGND sky130_fd_sc_hd__inv_2
Xsky130_fd_sc_hd__nand2_2_4 sky130_fd_sc_hd__nor2_2_0/B sky130_fd_sc_hd__or4_2_4/A sky130_fd_sc_hd__xor2_2_7/A VGND VPWR VPWR VGND sky130_fd_sc_hd__nand2_2
Xsky130_fd_sc_hd__or4_2_6 sky130_fd_sc_hd__or4_2_6/C sky130_fd_sc_hd__or4_2_6/A sky130_fd_sc_hd__or4_2_6/X sky130_fd_sc_hd__or4_2_6/B sky130_fd_sc_hd__or4_2_6/D VPWR VGND VPWR VGND sky130_fd_sc_hd__or4_2
Xsky130_fd_sc_hd__and4b_2_1 sky130_fd_sc_hd__nand4_2_5/D sky130_fd_sc_hd__or4b_2_2/C sky130_fd_sc_hd__or4b_2_3/A sky130_fd_sc_hd__or4b_2_3/B sky130_fd_sc_hd__or4b_2_3/C VPWR VGND VPWR VGND sky130_fd_sc_hd__and4b_2
Xsky130_fd_sc_hd__nor3_2_1 sky130_fd_sc_hd__nor3_2_1/C sky130_fd_sc_hd__nor3_2_1/Y sky130_fd_sc_hd__or2_2_9/B sky130_fd_sc_hd__nor3_2_1/B VGND VPWR VPWR VGND sky130_fd_sc_hd__nor3_2
Xsky130_fd_sc_hd__o32a_2_3 sky130_fd_sc_hd__or2_2_10/X sky130_fd_sc_hd__or2_2_12/A sky130_fd_sc_hd__o32a_2_3/A3 sky130_fd_sc_hd__o32a_2_3/A2 sky130_fd_sc_hd__o32a_2_3/A1 sky130_fd_sc_hd__o32a_2_3/X VGND VPWR VPWR VGND sky130_fd_sc_hd__o32a_2
Xsky130_fd_sc_hd__xor2_2_17 sky130_fd_sc_hd__xor2_2_17/X sky130_fd_sc_hd__xor2_2_17/B sky130_fd_sc_hd__xor2_2_19/A VPWR VGND VPWR VGND sky130_fd_sc_hd__xor2_2
Xsky130_fd_sc_hd__a21boi_2_2 sky130_fd_sc_hd__or2_2_11/B sky130_fd_sc_hd__nand3_2_1/Y sky130_fd_sc_hd__inv_2_21/Y sky130_fd_sc_hd__dfxtp_2_0/D VPWR VGND VPWR VGND sky130_fd_sc_hd__a21boi_2
Xsky130_fd_sc_hd__clkbuf_4_6 sky130_fd_sc_hd__clkbuf_4_6/X sky130_fd_sc_hd__clkbuf_8_6/X VGND VPWR VPWR VGND sky130_fd_sc_hd__clkbuf_4
Xsky130_fd_sc_hd__and3_2_0 sky130_fd_sc_hd__or3_2_0/B sky130_fd_sc_hd__and3_2_0/X sky130_fd_sc_hd__or2_2_4/A sky130_fd_sc_hd__and3_2_0/C VPWR VGND VPWR VGND sky130_fd_sc_hd__and3_2
Xsky130_fd_sc_hd__nand2b_2_7 sky130_fd_sc_hd__or3b_2_0/A sky130_fd_sc_hd__a21o_2_6/A2 sky130_fd_sc_hd__or2_2_9/B VGND VPWR sky130_fd_sc_hd__o31a_2_0/VPB VGND sky130_fd_sc_hd__nand2b_2
Xsky130_fd_sc_hd__o22a_2_2 sky130_fd_sc_hd__and2_2_8/A sky130_fd_sc_hd__o22a_2_2/X sky130_fd_sc_hd__and2_2_8/B sky130_fd_sc_hd__or2_2_8/B sky130_fd_sc_hd__nor3_2_1/B VGND VPWR sky130_fd_sc_hd__o22a_2_2/VPB VGND sky130_fd_sc_hd__o22a_2
Xsky130_fd_sc_hd__a221o_2_1 sky130_fd_sc_hd__a221o_2_1/X sky130_fd_sc_hd__conb_1_2/HI sky130_fd_sc_hd__or4bb_2_0/X sky130_fd_sc_hd__mux2_1_12/A0 sky130_fd_sc_hd__mux2_1_12/A1 VGND VPWR sky130_fd_sc_hd__a22o_2_2/X VPWR VGND sky130_fd_sc_hd__a221o_2
Xsky130_fd_sc_hd__o21a_2_20 sky130_fd_sc_hd__inv_2_18/A sky130_fd_sc_hd__or4_2_7/X sky130_fd_sc_hd__nor2_2_43/Y sky130_fd_sc_hd__o21a_2_20/X VGND VPWR VPWR VGND sky130_fd_sc_hd__o21a_2
Xsky130_fd_sc_hd__and2_2_10 sky130_fd_sc_hd__or4_2_5/A sky130_fd_sc_hd__and3_2_5/B sky130_fd_sc_hd__or4_2_5/B VPWR VGND VPWR VGND sky130_fd_sc_hd__and2_2
Xsky130_fd_sc_hd__and2b_2_11 sky130_fd_sc_hd__inv_2_7/A enable sky130_fd_sc_hd__or2_2_11/A VPWR VGND sky130_fd_sc_hd__diode_2_1/VPB VGND sky130_fd_sc_hd__and2b_2
Xsky130_fd_sc_hd__and2b_2_22 sky130_fd_sc_hd__and3_2_5/A sky130_fd_sc_hd__o21a_2_16/A1 sky130_fd_sc_hd__nand4_2_4/C VPWR VGND VPWR VGND sky130_fd_sc_hd__and2b_2
Xsky130_fd_sc_hd__a211o_2_0 sky130_fd_sc_hd__a211o_2_0/X sky130_fd_sc_hd__a32o_2_1/X sky130_fd_sc_hd__or2_2_5/A sky130_fd_sc_hd__o221a_2_0/X sky130_fd_sc_hd__or3_2_7/A VGND VPWR VPWR VGND sky130_fd_sc_hd__a211o_2
Xsky130_fd_sc_hd__dfxtp_2_0 sky130_fd_sc_hd__or2_2_8/B sky130_fd_sc_hd__dfxtp_2_3/CLK sky130_fd_sc_hd__dfxtp_2_0/D VPWR VGND VPWR VGND sky130_fd_sc_hd__dfxtp_2
Xsky130_fd_sc_hd__a21oi_2_14 sky130_fd_sc_hd__or2_2_9/B sky130_fd_sc_hd__or2_2_8/B sky130_fd_sc_hd__or3b_2_0/A sky130_fd_sc_hd__o221a_2_2/B2 VGND VPWR VPWR VGND sky130_fd_sc_hd__a21oi_2
Xsky130_fd_sc_hd__dfrtp_2_23 sky130_fd_sc_hd__or3_2_8/A rst_n sky130_fd_sc_hd__nor2_2_30/Y sky130_fd_sc_hd__dfrtp_2_8/CLK VGND VPWR VPWR VGND sky130_fd_sc_hd__dfrtp_2
Xsky130_fd_sc_hd__dfrtp_2_12 sky130_fd_sc_hd__o21a_2_8/A1 rst_n sky130_fd_sc_hd__nand2b_2_3/Y sky130_fd_sc_hd__clkbuf_8_1/X VGND VPWR VPWR VGND sky130_fd_sc_hd__dfrtp_2
Xsky130_fd_sc_hd__dfrtp_2_34 sky130_fd_sc_hd__mux2_1_8/A0 rst_n sky130_fd_sc_hd__mux2_1_8/X sky130_fd_sc_hd__clkbuf_8_2/X VGND VPWR VPWR VGND sky130_fd_sc_hd__dfrtp_2
Xsky130_fd_sc_hd__dfrtp_2_67 sky130_fd_sc_hd__o21a_2_24/A1 rst_n sky130_fd_sc_hd__dfrtp_2_67/D sky130_fd_sc_hd__clkbuf_8_11/X VGND VPWR VPWR VGND sky130_fd_sc_hd__dfrtp_2
Xsky130_fd_sc_hd__dfrtp_2_56 sky130_fd_sc_hd__nand4_2_4/C rst_n sky130_fd_sc_hd__o21a_2_16/X sky130_fd_sc_hd__clkbuf_4_9/A VGND VPWR VPWR VGND sky130_fd_sc_hd__dfrtp_2
Xsky130_fd_sc_hd__dfrtp_2_45 sky130_fd_sc_hd__or4_2_4/D rst_n sky130_fd_sc_hd__dfrtp_2_45/D sky130_fd_sc_hd__clkbuf_8_5/X VGND VPWR VPWR VGND sky130_fd_sc_hd__dfrtp_2
Xsky130_fd_sc_hd__dfrtp_2_78 sky130_fd_sc_hd__nand4_2_10/C rst_n sky130_fd_sc_hd__o21a_2_28/X sky130_fd_sc_hd__clkbuf_8_10/X VGND VPWR VPWR VGND sky130_fd_sc_hd__dfrtp_2
Xsky130_fd_sc_hd__inv_2_15 sky130_fd_sc_hd__or3b_2_0/A sky130_fd_sc_hd__inv_2_15/Y VPWR VGND sky130_fd_sc_hd__inv_2_15/VPB VGND sky130_fd_sc_hd__inv_2
Xsky130_fd_sc_hd__nand2_2_5 sky130_fd_sc_hd__nand2_2_5/Y sky130_fd_sc_hd__or3_2_0/B sky130_fd_sc_hd__or3_2_2/B VGND VPWR VPWR VGND sky130_fd_sc_hd__nand2_2
Xsky130_fd_sc_hd__or4_2_7 sky130_fd_sc_hd__or4_2_7/C sky130_fd_sc_hd__or4_2_7/A sky130_fd_sc_hd__or4_2_7/X sky130_fd_sc_hd__or4_2_7/B sky130_fd_sc_hd__or4_2_7/D VPWR VGND VPWR VGND sky130_fd_sc_hd__or4_2
Xsky130_fd_sc_hd__and4b_2_2 sky130_fd_sc_hd__and4b_2_2/X sky130_fd_sc_hd__or4_2_4/D sky130_fd_sc_hd__or4_2_4/B sky130_fd_sc_hd__or4_2_4/A sky130_fd_sc_hd__or4_2_4/C VPWR VGND VPWR VGND sky130_fd_sc_hd__and4b_2
Xsky130_fd_sc_hd__buf_2_0 VPWR VGND sky130_fd_sc_hd__buf_2_0/X sky130_fd_sc_hd__or4_2_4/X VPWR VGND sky130_fd_sc_hd__buf_2
Xsky130_fd_sc_hd__inv_2_0 sky130_fd_sc_hd__or3_2_3/C sky130_fd_sc_hd__inv_2_0/Y VPWR VGND VPWR VGND sky130_fd_sc_hd__inv_2
Xsky130_fd_sc_hd__nor3_2_2 sky130_fd_sc_hd__or3_2_8/X sky130_fd_sc_hd__nor3_2_2/Y sky130_fd_sc_hd__nor3_2_2/A sky130_fd_sc_hd__nor3_2_2/B VGND VPWR VPWR VGND sky130_fd_sc_hd__nor3_2
Xsky130_fd_sc_hd__xor2_2_18 sky130_fd_sc_hd__xor2_2_18/X sky130_fd_sc_hd__o32a_2_2/X sky130_fd_sc_hd__xor2_2_19/A VPWR VGND VPWR VGND sky130_fd_sc_hd__xor2_2
Xsky130_fd_sc_hd__a21boi_2_3 sky130_fd_sc_hd__or2_2_11/B sky130_fd_sc_hd__and3_2_25/C sky130_fd_sc_hd__or3b_2_0/A sky130_fd_sc_hd__dfxtp_2_2/D VPWR VGND sky130_fd_sc_hd__and2_2_16/VPB VGND sky130_fd_sc_hd__a21boi_2
Xsky130_fd_sc_hd__clkbuf_4_7 sky130_fd_sc_hd__clkbuf_4_7/X sky130_fd_sc_hd__clkbuf_8_7/X VGND VPWR VPWR VGND sky130_fd_sc_hd__clkbuf_4
Xsky130_fd_sc_hd__and3_2_1 sky130_fd_sc_hd__inv_2_4/Y sky130_fd_sc_hd__and3_2_1/X sky130_fd_sc_hd__or2_2_4/A sky130_fd_sc_hd__and3_2_1/C VPWR VGND VPWR VGND sky130_fd_sc_hd__and3_2
Xsky130_fd_sc_hd__nand2b_2_8 sky130_fd_sc_hd__or2_2_9/B sky130_fd_sc_hd__nand2b_2_8/Y sky130_fd_sc_hd__or2_2_8/B VGND VPWR VPWR VGND sky130_fd_sc_hd__nand2b_2
Xsky130_fd_sc_hd__o22a_2_3 sky130_fd_sc_hd__or2_2_10/X sky130_fd_sc_hd__o22a_2_3/X sky130_fd_sc_hd__o22a_2_3/B1 sky130_fd_sc_hd__xor2_2_19/A sky130_fd_sc_hd__o22a_2_3/B2 VGND VPWR VPWR VGND sky130_fd_sc_hd__o22a_2
Xsky130_fd_sc_hd__a221o_2_2 sky130_fd_sc_hd__a221o_2_2/X sky130_fd_sc_hd__xor2_2_19/B sky130_fd_sc_hd__inv_2_7/A sky130_fd_sc_hd__nor2_2_39/Y sky130_fd_sc_hd__xor2_2_16/A VGND VPWR sky130_fd_sc_hd__nor2_2_46/Y VPWR VGND sky130_fd_sc_hd__a221o_2
Xsky130_fd_sc_hd__o21a_2_21 sky130_fd_sc_hd__o21a_2_21/A1 sky130_fd_sc_hd__a31o_2_24/X sky130_fd_sc_hd__nand4_2_9/Y sky130_fd_sc_hd__o21a_2_21/X VGND VPWR VPWR VGND sky130_fd_sc_hd__o21a_2
Xsky130_fd_sc_hd__o21a_2_10 sky130_fd_sc_hd__and2b_2_3/B sky130_fd_sc_hd__a31o_2_3/X sky130_fd_sc_hd__nand4_2_1/Y sky130_fd_sc_hd__o21a_2_10/X VGND VPWR VPWR VGND sky130_fd_sc_hd__o21a_2
Xsky130_fd_sc_hd__and2_2_11 sky130_fd_sc_hd__or4_2_9/A sky130_fd_sc_hd__and4_2_6/A sky130_fd_sc_hd__or4_2_9/B VPWR VGND VPWR VGND sky130_fd_sc_hd__and2_2
Xsky130_fd_sc_hd__and2b_2_23 sky130_fd_sc_hd__and4_2_6/B sky130_fd_sc_hd__o21a_2_19/A1 sky130_fd_sc_hd__nand4_2_7/C VPWR VGND VPWR VGND sky130_fd_sc_hd__and2b_2
Xsky130_fd_sc_hd__and2b_2_12 sky130_fd_sc_hd__and3_2_17/C sky130_fd_sc_hd__or2_2_9/A sky130_fd_sc_hd__or2_2_9/B VPWR VGND VPWR VGND sky130_fd_sc_hd__and2b_2
Xsky130_fd_sc_hd__a211o_2_1 sky130_fd_sc_hd__a211o_2_1/X sky130_fd_sc_hd__or2_2_4/B sky130_fd_sc_hd__or4_2_0/A sky130_fd_sc_hd__mux2_1_4/X sky130_fd_sc_hd__or4_2_0/B VGND VPWR VPWR VGND sky130_fd_sc_hd__a211o_2
Xsky130_fd_sc_hd__dfxtp_2_1 sky130_fd_sc_hd__or2_2_9/A sky130_fd_sc_hd__dfxtp_2_2/CLK sky130_fd_sc_hd__dfxtp_2_1/D VPWR VGND VPWR VGND sky130_fd_sc_hd__dfxtp_2
Xsky130_fd_sc_hd__a21oi_2_15 sky130_fd_sc_hd__mux2_1_20/X sky130_fd_sc_hd__nor2_2_32/B sky130_fd_sc_hd__or2_2_8/X sky130_fd_sc_hd__a22o_2_21/B2 VGND VPWR VPWR VGND sky130_fd_sc_hd__a21oi_2
Xsky130_fd_sc_hd__dfrtp_2_24 sky130_fd_sc_hd__and4_2_3/A rst_n sky130_fd_sc_hd__a32o_2_2/X sky130_fd_sc_hd__dfrtp_2_8/CLK VGND VPWR VPWR VGND sky130_fd_sc_hd__dfrtp_2
Xsky130_fd_sc_hd__dfrtp_2_13 sky130_fd_sc_hd__or4_2_2/A rst_n sky130_fd_sc_hd__a21o_2_1/X sky130_fd_sc_hd__clkbuf_8_0/X VGND VPWR VPWR VGND sky130_fd_sc_hd__dfrtp_2
Xsky130_fd_sc_hd__dfrtp_2_68 sky130_fd_sc_hd__o21a_2_25/A1 rst_n sky130_fd_sc_hd__dfrtp_2_68/D sky130_fd_sc_hd__clkbuf_8_10/X VGND VPWR VPWR VGND sky130_fd_sc_hd__dfrtp_2
Xsky130_fd_sc_hd__dfrtp_2_57 sky130_fd_sc_hd__o21a_2_19/A1 rst_n sky130_fd_sc_hd__dfrtp_2_57/D sky130_fd_sc_hd__clkbuf_8_8/X VGND VPWR sky130_fd_sc_hd__dfrtp_2_57/VPB VGND sky130_fd_sc_hd__dfrtp_2
Xsky130_fd_sc_hd__dfrtp_2_35 sky130_fd_sc_hd__mux2_1_16/A0 rst_n sky130_fd_sc_hd__mux2_1_16/X sky130_fd_sc_hd__clkbuf_8_2/X VGND VPWR VPWR VGND sky130_fd_sc_hd__dfrtp_2
Xsky130_fd_sc_hd__dfrtp_2_46 sky130_fd_sc_hd__or4_2_4/C rst_n sky130_fd_sc_hd__xor2_2_11/X sky130_fd_sc_hd__clkbuf_8_5/X VGND VPWR VPWR VGND sky130_fd_sc_hd__dfrtp_2
Xsky130_fd_sc_hd__dfrtp_2_79 sky130_fd_sc_hd__or4_2_8/A rst_n sky130_fd_sc_hd__a21o_2_15/X sky130_fd_sc_hd__clkbuf_8_9/X VGND VPWR VPWR VGND sky130_fd_sc_hd__dfrtp_2
Xsky130_fd_sc_hd__inv_2_16 sky130_fd_sc_hd__inv_2_16/A sky130_fd_sc_hd__or4_2_5/B VPWR VGND VPWR VGND sky130_fd_sc_hd__inv_2
Xsky130_fd_sc_hd__nand2_2_6 sky130_fd_sc_hd__nor2_2_5/A sky130_fd_sc_hd__xor2_2_3/A sky130_fd_sc_hd__or3_2_3/A VGND VPWR VPWR VGND sky130_fd_sc_hd__nand2_2
Xsky130_fd_sc_hd__or4_2_8 sky130_fd_sc_hd__or4_2_8/C sky130_fd_sc_hd__or4_2_8/A sky130_fd_sc_hd__or4_2_8/X sky130_fd_sc_hd__or4_2_8/B sky130_fd_sc_hd__or4_2_8/D VPWR VGND VPWR VGND sky130_fd_sc_hd__or4_2
Xsky130_fd_sc_hd__and4b_2_3 sky130_fd_sc_hd__and4b_2_3/X sky130_fd_sc_hd__or2_2_11/B sky130_fd_sc_hd__and4b_2_3/D sky130_fd_sc_hd__and3_2_6/X sky130_fd_sc_hd__or2_2_11/A VPWR VGND VPWR VGND sky130_fd_sc_hd__and4b_2
Xsky130_fd_sc_hd__nor3_2_3 sky130_fd_sc_hd__nor3_2_3/C sky130_fd_sc_hd__nor3_2_3/Y sky130_fd_sc_hd__nor3_2_3/A sky130_fd_sc_hd__nor3_2_3/B VGND VPWR VPWR VGND sky130_fd_sc_hd__nor3_2
Xsky130_fd_sc_hd__inv_2_1 sky130_fd_sc_hd__inv_2_1/A sky130_fd_sc_hd__or4_2_1/B VPWR VGND VPWR VGND sky130_fd_sc_hd__inv_2
Xsky130_fd_sc_hd__xor2_2_19 sky130_fd_sc_hd__xor2_2_19/X sky130_fd_sc_hd__xor2_2_19/B sky130_fd_sc_hd__xor2_2_19/A VPWR VGND VPWR VGND sky130_fd_sc_hd__xor2_2
Xsky130_fd_sc_hd__clkbuf_4_8 sky130_fd_sc_hd__clkbuf_4_8/X sky130_fd_sc_hd__clkbuf_8_8/X VGND VPWR VPWR VGND sky130_fd_sc_hd__clkbuf_4
Xsky130_fd_sc_hd__or3b_2_0 sky130_fd_sc_hd__or3b_2_0/A sky130_fd_sc_hd__or2_2_9/B sky130_fd_sc_hd__or2_2_9/A sky130_fd_sc_hd__or3b_2_0/X VPWR VGND VPWR VGND sky130_fd_sc_hd__or3b_2
Xsky130_fd_sc_hd__xor2_2_0 sky130_fd_sc_hd__xor2_2_0/X sky130_fd_sc_hd__xor2_2_0/B sky130_fd_sc_hd__xor2_2_7/A VPWR VGND VPWR VGND sky130_fd_sc_hd__xor2_2
Xsky130_fd_sc_hd__and3_2_2 sky130_fd_sc_hd__and3_2_2/B sky130_fd_sc_hd__or3_2_5/C sky130_fd_sc_hd__and3_2_2/A sky130_fd_sc_hd__and3_2_2/C VPWR VGND VPWR VGND sky130_fd_sc_hd__and3_2
Xsky130_fd_sc_hd__nand2b_2_9 sky130_fd_sc_hd__or2_2_8/B sky130_fd_sc_hd__o32ai_2_0/B1 sky130_fd_sc_hd__or2_2_9/B VGND VPWR VPWR VGND sky130_fd_sc_hd__nand2b_2
Xsky130_fd_sc_hd__a221o_2_3 sky130_fd_sc_hd__o22a_2_3/B2 sky130_fd_sc_hd__nor2_2_34/Y sky130_fd_sc_hd__inv_2_7/A sky130_fd_sc_hd__nor3b_2_0/B sky130_fd_sc_hd__or2_2_12/A VGND VPWR sky130_fd_sc_hd__nor2_2_39/Y VPWR VGND sky130_fd_sc_hd__a221o_2
Xsky130_fd_sc_hd__o21a_2_22 sky130_fd_sc_hd__inv_2_19/A sky130_fd_sc_hd__or4_2_8/X sky130_fd_sc_hd__nor2_2_44/Y sky130_fd_sc_hd__o21a_2_22/X VGND VPWR VPWR VGND sky130_fd_sc_hd__o21a_2
Xsky130_fd_sc_hd__o21a_2_11 sky130_fd_sc_hd__or3_2_8/B sky130_fd_sc_hd__xnor2_2_11/B sky130_fd_sc_hd__and3_2_11/X sky130_fd_sc_hd__o21a_2_11/X VGND VPWR VPWR VGND sky130_fd_sc_hd__o21a_2
Xsky130_fd_sc_hd__and2_2_12 sky130_fd_sc_hd__or4_2_7/A sky130_fd_sc_hd__and4_2_6/D sky130_fd_sc_hd__or4_2_7/B VPWR VGND VPWR VGND sky130_fd_sc_hd__and2_2
Xsky130_fd_sc_hd__and2b_2_13 sky130_fd_sc_hd__nor2_2_32/B sky130_fd_sc_hd__or3b_2_0/A sky130_fd_sc_hd__or2_2_9/A VPWR VGND VPWR VGND sky130_fd_sc_hd__and2b_2
Xsky130_fd_sc_hd__and2b_2_24 sky130_fd_sc_hd__and4_2_6/C sky130_fd_sc_hd__o21a_2_23/A1 sky130_fd_sc_hd__nand4_2_8/C VPWR VGND VPWR VGND sky130_fd_sc_hd__and2b_2
Xsky130_fd_sc_hd__a211o_2_2 sky130_fd_sc_hd__a211o_2_2/X sky130_fd_sc_hd__nand2_2_9/Y sky130_fd_sc_hd__or2_2_4/A sky130_fd_sc_hd__or4_2_0/D sky130_fd_sc_hd__or4_2_0/A VGND VPWR VPWR VGND sky130_fd_sc_hd__a211o_2
Xsky130_fd_sc_hd__dfxtp_2_2 sky130_fd_sc_hd__or3b_2_0/A sky130_fd_sc_hd__dfxtp_2_2/CLK sky130_fd_sc_hd__dfxtp_2_2/D VPWR VGND VPWR VGND sky130_fd_sc_hd__dfxtp_2
Xsky130_fd_sc_hd__a21oi_2_16 sky130_fd_sc_hd__or3_2_9/A sky130_fd_sc_hd__o31a_2_1/B1 sky130_fd_sc_hd__inv_2_12/A sky130_fd_sc_hd__xnor2_2_14/B VGND VPWR VPWR VGND sky130_fd_sc_hd__a21oi_2
Xsky130_fd_sc_hd__dfrtp_2_25 sky130_fd_sc_hd__and4_2_3/B rst_n sky130_fd_sc_hd__dfrtp_2_25/D sky130_fd_sc_hd__clkbuf_8_3/X VGND VPWR VPWR VGND sky130_fd_sc_hd__dfrtp_2
Xsky130_fd_sc_hd__dfrtp_2_14 sky130_fd_sc_hd__o21a_2_4/A1 rst_n sky130_fd_sc_hd__nand2b_2_1/Y sky130_fd_sc_hd__clkbuf_8_0/X VGND VPWR VPWR VGND sky130_fd_sc_hd__dfrtp_2
Xsky130_fd_sc_hd__dfrtp_2_47 sky130_fd_sc_hd__or2_2_11/A rst_n sky130_fd_sc_hd__a31o_2_13/X sky130_fd_sc_hd__clkbuf_8_8/X VGND VPWR VPWR VGND sky130_fd_sc_hd__dfrtp_2
Xsky130_fd_sc_hd__dfrtp_2_58 sky130_fd_sc_hd__o21a_2_18/A1 rst_n sky130_fd_sc_hd__dfrtp_2_58/D sky130_fd_sc_hd__clkbuf_4_9/A VGND VPWR VPWR VGND sky130_fd_sc_hd__dfrtp_2
Xsky130_fd_sc_hd__dfrtp_2_36 sky130_fd_sc_hd__mux2_1_12/A0 rst_n sky130_fd_sc_hd__mux2_1_12/X sky130_fd_sc_hd__clkbuf_8_6/X VGND VPWR VPWR VGND sky130_fd_sc_hd__dfrtp_2
Xsky130_fd_sc_hd__dfrtp_2_69 sky130_fd_sc_hd__or4_2_6/A rst_n sky130_fd_sc_hd__a21o_2_16/X sky130_fd_sc_hd__clkbuf_8_10/X VGND VPWR VPWR VGND sky130_fd_sc_hd__dfrtp_2
Xsky130_fd_sc_hd__o21bai_2_0 sky130_fd_sc_hd__xnor2_2_6/A sky130_fd_sc_hd__o21bai_2_0/Y sky130_fd_sc_hd__o32ai_2_0/B1 sky130_fd_sc_hd__nor3_2_1/B VGND VPWR VPWR VGND sky130_fd_sc_hd__o21bai_2
Xsky130_fd_sc_hd__inv_2_17 sky130_fd_sc_hd__inv_2_17/A sky130_fd_sc_hd__or4_2_9/B VPWR VGND VPWR VGND sky130_fd_sc_hd__inv_2
Xsky130_fd_sc_hd__nand2_2_7 sky130_fd_sc_hd__nor2_2_9/B sky130_fd_sc_hd__nor2_2_8/A sky130_fd_sc_hd__nor2_2_0/B VGND VPWR VPWR VGND sky130_fd_sc_hd__nand2_2
Xsky130_fd_sc_hd__or4_2_9 sky130_fd_sc_hd__or4_2_9/C sky130_fd_sc_hd__or4_2_9/A sky130_fd_sc_hd__or4_2_9/X sky130_fd_sc_hd__or4_2_9/B sky130_fd_sc_hd__or4_2_9/D VPWR VGND VPWR VGND sky130_fd_sc_hd__or4_2
Xsky130_fd_sc_hd__inv_2_2 sky130_fd_sc_hd__inv_2_2/A sky130_fd_sc_hd__or4_2_2/B VPWR VGND VPWR VGND sky130_fd_sc_hd__inv_2
Xsky130_fd_sc_hd__a41oi_2_0 sky130_fd_sc_hd__inv_2_7/A sky130_fd_sc_hd__or4_2_4/C sky130_fd_sc_hd__or4_2_4/A sky130_fd_sc_hd__or4_2_4/D sky130_fd_sc_hd__or4_2_4/B sky130_fd_sc_hd__a41oi_2_0/Y VPWR VGND VPWR VGND sky130_fd_sc_hd__a41oi_2
Xsky130_fd_sc_hd__clkbuf_4_9 sky130_fd_sc_hd__clkbuf_4_9/X sky130_fd_sc_hd__clkbuf_4_9/A VGND VPWR sky130_fd_sc_hd__clkbuf_4_9/VPB VGND sky130_fd_sc_hd__clkbuf_4
Xsky130_fd_sc_hd__xor2_2_1 sky130_fd_sc_hd__xor2_2_1/X sky130_fd_sc_hd__xor2_2_1/B sky130_fd_sc_hd__or4_2_4/C VPWR VGND VPWR VGND sky130_fd_sc_hd__xor2_2
Xsky130_fd_sc_hd__and3_2_3 sky130_fd_sc_hd__and3_2_3/B sky130_fd_sc_hd__and3_2_3/X sky130_fd_sc_hd__or4_2_0/B sky130_fd_sc_hd__and3_2_3/C VPWR VGND sky130_fd_sc_hd__and3_2_3/VPB VGND sky130_fd_sc_hd__and3_2
Xsky130_fd_sc_hd__a221o_2_4 sky130_fd_sc_hd__a221o_2_4/X sky130_fd_sc_hd__nor2_2_39/Y sky130_fd_sc_hd__inv_2_7/A sky130_fd_sc_hd__xor2_2_14/B sky130_fd_sc_hd__xor2_2_19/A VGND VPWR sky130_fd_sc_hd__o21a_2_14/X VPWR VGND sky130_fd_sc_hd__a221o_2
Xsky130_fd_sc_hd__o21a_2_23 sky130_fd_sc_hd__o21a_2_23/A1 sky130_fd_sc_hd__a31o_2_19/X sky130_fd_sc_hd__nand4_2_8/Y sky130_fd_sc_hd__o21a_2_23/X VGND VPWR VPWR VGND sky130_fd_sc_hd__o21a_2
Xsky130_fd_sc_hd__o21a_2_12 sky130_fd_sc_hd__o21a_2_12/A1 sky130_fd_sc_hd__a31o_2_9/X sky130_fd_sc_hd__xnor2_2_11/B sky130_fd_sc_hd__o21a_2_12/X VGND VPWR VPWR VGND sky130_fd_sc_hd__o21a_2
Xsky130_fd_sc_hd__and2_2_13 sky130_fd_sc_hd__or4_2_8/A sky130_fd_sc_hd__and4_2_5/B sky130_fd_sc_hd__or4_2_8/B VPWR VGND VPWR VGND sky130_fd_sc_hd__and2_2
Xsky130_fd_sc_hd__and2b_2_14 sky130_fd_sc_hd__o31a_2_2/A2 sky130_fd_sc_hd__or3b_2_0/A sky130_fd_sc_hd__or2_2_9/A VPWR VGND VPWR VGND sky130_fd_sc_hd__and2b_2
Xsky130_fd_sc_hd__and2b_2_25 sky130_fd_sc_hd__and4_2_5/A sky130_fd_sc_hd__o21a_2_21/A1 sky130_fd_sc_hd__nand4_2_9/C VPWR VGND VPWR VGND sky130_fd_sc_hd__and2b_2
Xsky130_fd_sc_hd__a211o_2_3 sky130_fd_sc_hd__a211o_2_3/X sky130_fd_sc_hd__or2_2_9/B sky130_fd_sc_hd__or3b_2_0/A sky130_fd_sc_hd__inv_2_13/Y sky130_fd_sc_hd__o31a_2_1/A3 VGND VPWR VPWR VGND sky130_fd_sc_hd__a211o_2
Xsky130_fd_sc_hd__dfxtp_2_3 sky130_fd_sc_hd__or2_2_9/B sky130_fd_sc_hd__dfxtp_2_3/CLK sky130_fd_sc_hd__dfxtp_2_3/D VPWR VGND VPWR VGND sky130_fd_sc_hd__dfxtp_2
Xsky130_fd_sc_hd__a21oi_2_17 sky130_fd_sc_hd__or2_2_8/B sky130_fd_sc_hd__and3_2_17/C sky130_fd_sc_hd__or3b_2_0/A sky130_fd_sc_hd__a22o_2_7/A1 VGND VPWR VPWR VGND sky130_fd_sc_hd__a21oi_2
Xsky130_fd_sc_hd__dfrtp_2_15 sky130_fd_sc_hd__xor2_2_0/B rst_n sky130_fd_sc_hd__o211a_2_7/X sky130_fd_sc_hd__clkbuf_8_4/X VGND VPWR VPWR VGND sky130_fd_sc_hd__dfrtp_2
Xsky130_fd_sc_hd__dfrtp_2_48 sky130_fd_sc_hd__xor2_2_14/B rst_n sky130_fd_sc_hd__a221o_2_4/X sky130_fd_sc_hd__clkbuf_8_7/X VGND VPWR VPWR VGND sky130_fd_sc_hd__dfrtp_2
Xsky130_fd_sc_hd__dfrtp_2_26 sky130_fd_sc_hd__or3_2_8/B rst_n sky130_fd_sc_hd__o21a_2_11/X sky130_fd_sc_hd__clkbuf_8_3/X VGND VPWR VPWR VGND sky130_fd_sc_hd__dfrtp_2
Xsky130_fd_sc_hd__dfrtp_2_59 sky130_fd_sc_hd__o21a_2_16/A1 rst_n sky130_fd_sc_hd__dfrtp_2_59/D sky130_fd_sc_hd__clkbuf_4_9/A VGND VPWR VPWR VGND sky130_fd_sc_hd__dfrtp_2
Xsky130_fd_sc_hd__dfrtp_2_37 sky130_fd_sc_hd__inv_2_11/A rst_n sky130_fd_sc_hd__a31o_2_12/X sky130_fd_sc_hd__clkbuf_8_6/X VGND VPWR VPWR VGND sky130_fd_sc_hd__dfrtp_2
Xsky130_fd_sc_hd__inv_2_18 sky130_fd_sc_hd__inv_2_18/A sky130_fd_sc_hd__or4_2_7/B VPWR VGND VPWR VGND sky130_fd_sc_hd__inv_2
Xsky130_fd_sc_hd__nand2_2_8 sky130_fd_sc_hd__xnor2_2_0/A sky130_fd_sc_hd__or4_2_4/B sky130_fd_sc_hd__xor2_2_0/X VGND VPWR VPWR VGND sky130_fd_sc_hd__nand2_2
Xsky130_fd_sc_hd__inv_2_3 sky130_fd_sc_hd__inv_2_3/A sky130_fd_sc_hd__or4_2_3/B VPWR VGND VPWR VGND sky130_fd_sc_hd__inv_2
Xsky130_fd_sc_hd__mux2_1_20 sky130_fd_sc_hd__or2_2_9/B sky130_fd_sc_hd__or2_2_8/B sky130_fd_sc_hd__or2_2_9/A sky130_fd_sc_hd__mux2_1_20/X VGND VPWR sky130_fd_sc_hd__or2_2_8/VPB VGND sky130_fd_sc_hd__mux2_1
Xsky130_fd_sc_hd__xor2_2_2 sky130_fd_sc_hd__or3_2_3/B sky130_fd_sc_hd__xor2_2_2/B sky130_fd_sc_hd__xor2_2_2/A VPWR VGND VPWR VGND sky130_fd_sc_hd__xor2_2
Xsky130_fd_sc_hd__and3_2_4 sky130_fd_sc_hd__and3_2_4/B sky130_fd_sc_hd__and3_2_4/X sky130_fd_sc_hd__and3_2_4/A sky130_fd_sc_hd__or3_2_5/X VPWR VGND VPWR VGND sky130_fd_sc_hd__and3_2
Xsky130_fd_sc_hd__a221o_2_5 sky130_fd_sc_hd__dfstp_2_0/D sky130_fd_sc_hd__xor2_2_17/B sky130_fd_sc_hd__inv_2_7/A sky130_fd_sc_hd__nor2_2_39/Y sky130_fd_sc_hd__a22o_2_4/B2 VGND VPWR sky130_fd_sc_hd__nor2_2_40/Y VPWR VGND sky130_fd_sc_hd__a221o_2
Xsky130_fd_sc_hd__o21a_2_24 sky130_fd_sc_hd__o21a_2_24/A1 sky130_fd_sc_hd__a31o_2_20/X sky130_fd_sc_hd__o21a_2_24/A2 sky130_fd_sc_hd__o21a_2_24/X VGND VPWR VPWR VGND sky130_fd_sc_hd__o21a_2
Xsky130_fd_sc_hd__o21a_2_13 sky130_fd_sc_hd__inv_2_15/Y sky130_fd_sc_hd__inv_2_14/Y sky130_fd_sc_hd__o31a_2_2/A1 sky130_fd_sc_hd__o21a_2_13/X VGND VPWR VPWR VGND sky130_fd_sc_hd__o21a_2
Xsky130_fd_sc_hd__and2_2_14 sky130_fd_sc_hd__or4_2_6/A sky130_fd_sc_hd__and3_2_12/B sky130_fd_sc_hd__or4_2_6/B VPWR VGND VPWR VGND sky130_fd_sc_hd__and2_2
Xsky130_fd_sc_hd__a32o_2_0 sky130_fd_sc_hd__xor2_2_3/B sky130_fd_sc_hd__xor2_2_2/A sky130_fd_sc_hd__xor2_2_0/X sky130_fd_sc_hd__xor2_2_1/X sky130_fd_sc_hd__or4_2_4/B sky130_fd_sc_hd__xor2_2_3/A VGND VPWR VPWR VGND sky130_fd_sc_hd__a32o_2
Xsky130_fd_sc_hd__and2b_2_26 sky130_fd_sc_hd__and4_2_5/D sky130_fd_sc_hd__o21a_2_28/A1 sky130_fd_sc_hd__nand4_2_10/C VPWR VGND VPWR VGND sky130_fd_sc_hd__and2b_2
Xsky130_fd_sc_hd__and2b_2_15 sky130_fd_sc_hd__o32a_2_2/B1 sky130_fd_sc_hd__nand2_2_29/Y sky130_fd_sc_hd__or3_2_9/B VPWR VGND sky130_fd_sc_hd__nor2_2_34/VPB VGND sky130_fd_sc_hd__and2b_2
Xsky130_fd_sc_hd__a211o_2_4 sky130_fd_sc_hd__or3_2_15/A sky130_fd_sc_hd__or3_2_17/A sky130_fd_sc_hd__or2_2_9/A sky130_fd_sc_hd__or3_2_6/C sky130_fd_sc_hd__or3_2_6/B VGND VPWR VPWR VGND sky130_fd_sc_hd__a211o_2
Xsky130_fd_sc_hd__a21oi_2_18 sky130_fd_sc_hd__nor3_2_3/A sky130_fd_sc_hd__nor3_2_3/C sky130_fd_sc_hd__nor3_2_3/B sky130_fd_sc_hd__or3_2_17/C VGND VPWR VPWR VGND sky130_fd_sc_hd__a21oi_2
Xsky130_fd_sc_hd__dfrtp_2_16 sky130_fd_sc_hd__xor2_2_7/A rst_n sky130_fd_sc_hd__mux2_1_5/X sky130_fd_sc_hd__clkbuf_8_3/X VGND VPWR VPWR VGND sky130_fd_sc_hd__dfrtp_2
Xsky130_fd_sc_hd__dfrtp_2_49 sky130_fd_sc_hd__a22o_2_4/B2 rst_n sky130_fd_sc_hd__a31o_2_14/X sky130_fd_sc_hd__clkbuf_4_9/A VGND VPWR VPWR VGND sky130_fd_sc_hd__dfrtp_2
Xsky130_fd_sc_hd__dfrtp_2_27 sky130_fd_sc_hd__or2_2_7/A rst_n sky130_fd_sc_hd__a22o_2_1/X sky130_fd_sc_hd__clkbuf_8_4/X VGND VPWR VPWR VGND sky130_fd_sc_hd__dfrtp_2
Xsky130_fd_sc_hd__dfrtp_2_38 sky130_fd_sc_hd__a22o_2_2/B2 rst_n sky130_fd_sc_hd__mux2_1_11/X sky130_fd_sc_hd__clkbuf_8_6/X VGND VPWR VPWR VGND sky130_fd_sc_hd__dfrtp_2
Xsky130_fd_sc_hd__inv_2_19 sky130_fd_sc_hd__inv_2_19/A sky130_fd_sc_hd__or4_2_8/B VPWR VGND VPWR VGND sky130_fd_sc_hd__inv_2
Xsky130_fd_sc_hd__nand2_2_9 sky130_fd_sc_hd__nand2_2_9/Y sky130_fd_sc_hd__xor2_2_3/A sky130_fd_sc_hd__inv_2_4/A VGND VPWR VPWR VGND sky130_fd_sc_hd__nand2_2
Xsky130_fd_sc_hd__or3_2_0 sky130_fd_sc_hd__or3_2_3/A sky130_fd_sc_hd__or3_2_0/B sky130_fd_sc_hd__or3_2_0/X sky130_fd_sc_hd__or3_2_2/B VGND VPWR VPWR VGND sky130_fd_sc_hd__or3_2
Xsky130_fd_sc_hd__inv_2_4 sky130_fd_sc_hd__inv_2_4/A sky130_fd_sc_hd__inv_2_4/Y VPWR VGND VPWR VGND sky130_fd_sc_hd__inv_2
Xsky130_fd_sc_hd__mux2_1_10 sky130_fd_sc_hd__inv_2_7/A sky130_fd_sc_hd__mux2_1_8/A0 sky130_fd_sc_hd__mux2_1_12/A1 sky130_fd_sc_hd__mux2_1_10/X VGND VPWR VPWR VGND sky130_fd_sc_hd__mux2_1
Xsky130_fd_sc_hd__xor2_2_3 sky130_fd_sc_hd__or2_2_2/A sky130_fd_sc_hd__xor2_2_3/B sky130_fd_sc_hd__xor2_2_3/A VPWR VGND VPWR VGND sky130_fd_sc_hd__xor2_2
Xsky130_fd_sc_hd__and3_2_5 sky130_fd_sc_hd__and3_2_5/B sky130_fd_sc_hd__and3_2_6/C sky130_fd_sc_hd__and3_2_5/A sky130_fd_sc_hd__and3_2_5/C VPWR VGND sky130_fd_sc_hd__and4_2_0/VPB VGND sky130_fd_sc_hd__and3_2
Xsky130_fd_sc_hd__o21a_2_25 sky130_fd_sc_hd__o21a_2_25/A1 sky130_fd_sc_hd__a31o_2_21/X sky130_fd_sc_hd__o21a_2_25/A2 sky130_fd_sc_hd__o21a_2_25/X VGND VPWR VPWR VGND sky130_fd_sc_hd__o21a_2
Xsky130_fd_sc_hd__o21a_2_14 sky130_fd_sc_hd__xor2_2_13/X sky130_fd_sc_hd__o21a_2_14/B1 sky130_fd_sc_hd__xor2_2_14/X sky130_fd_sc_hd__o21a_2_14/X VGND VPWR VPWR VGND sky130_fd_sc_hd__o21a_2
Xsky130_fd_sc_hd__and2_2_15 sky130_fd_sc_hd__inv_2_6/Y sky130_fd_sc_hd__and2_2_15/X sky130_fd_sc_hd__and4_2_3/X VPWR VGND sky130_fd_sc_hd__diode_2_9/VPB VGND sky130_fd_sc_hd__and2_2
Xsky130_fd_sc_hd__a32o_2_1 sky130_fd_sc_hd__a32o_2_1/B2 sky130_fd_sc_hd__a32o_2_1/X sky130_fd_sc_hd__o21a_2_3/A2 sky130_fd_sc_hd__or2_2_4/X sky130_fd_sc_hd__or4_2_0/A sky130_fd_sc_hd__o22a_2_0/X VGND VPWR VPWR VGND sky130_fd_sc_hd__a32o_2
Xsky130_fd_sc_hd__and2b_2_27 sky130_fd_sc_hd__and3_2_12/C sky130_fd_sc_hd__o21a_2_25/A1 sky130_fd_sc_hd__nand4_2_13/C VPWR VGND VPWR VGND sky130_fd_sc_hd__and2b_2
Xsky130_fd_sc_hd__and2b_2_16 sky130_fd_sc_hd__and2b_2_16/X sky130_fd_sc_hd__or2_2_10/A sky130_fd_sc_hd__inv_2_7/A VPWR VGND VPWR VGND sky130_fd_sc_hd__and2b_2
Xsky130_fd_sc_hd__a21oi_2_19 sky130_fd_sc_hd__nor2_2_46/A sky130_fd_sc_hd__xor2_2_14/X sky130_fd_sc_hd__xor2_2_13/X sky130_fd_sc_hd__o21a_2_14/B1 VGND VPWR VPWR VGND sky130_fd_sc_hd__a21oi_2
Xsky130_fd_sc_hd__a22o_2_0 sky130_fd_sc_hd__nand2_2_5/Y sky130_fd_sc_hd__or3_2_4/B sky130_fd_sc_hd__a22o_2_0/X sky130_fd_sc_hd__or2_2_4/A sky130_fd_sc_hd__or3_2_3/C VPWR VGND VPWR VGND sky130_fd_sc_hd__a22o_2
Xsky130_fd_sc_hd__dfrtp_2_28 sky130_fd_sc_hd__inv_2_6/A rst_n sky130_fd_sc_hd__a31o_2_11/X sky130_fd_sc_hd__clkbuf_8_4/X VGND VPWR VPWR VGND sky130_fd_sc_hd__dfrtp_2
Xsky130_fd_sc_hd__dfrtp_2_17 sky130_fd_sc_hd__xor2_2_9/A rst_n sky130_fd_sc_hd__xor2_2_9/X sky130_fd_sc_hd__clkbuf_8_4/X VGND VPWR VPWR VGND sky130_fd_sc_hd__dfrtp_2
Xsky130_fd_sc_hd__dfrtp_2_39 sky130_fd_sc_hd__mux2_1_19/A0 rst_n sky130_fd_sc_hd__mux2_1_19/X sky130_fd_sc_hd__clkbuf_8_8/X VGND VPWR sky130_fd_sc_hd__dfrtp_2_39/VPB VGND sky130_fd_sc_hd__dfrtp_2
Xsky130_fd_sc_hd__or3_2_1 sky130_fd_sc_hd__or4_2_0/A sky130_fd_sc_hd__or3_2_1/B sky130_fd_sc_hd__or3_2_1/X sky130_fd_sc_hd__or3_2_1/C VGND VPWR VPWR VGND sky130_fd_sc_hd__or3_2
Xsky130_fd_sc_hd__inv_2_5 sky130_fd_sc_hd__inv_2_5/A sky130_fd_sc_hd__inv_2_5/Y VPWR VGND VPWR VGND sky130_fd_sc_hd__inv_2
Xsky130_fd_sc_hd__mux2_1_11 sky130_fd_sc_hd__inv_2_7/A sky130_fd_sc_hd__mux2_1_12/A0 sky130_fd_sc_hd__a22o_2_2/B2 sky130_fd_sc_hd__mux2_1_11/X VGND VPWR VPWR VGND sky130_fd_sc_hd__mux2_1
Xsky130_fd_sc_hd__xor2_2_4 sky130_fd_sc_hd__xor2_2_4/X sky130_fd_sc_hd__xor2_2_7/X sky130_fd_sc_hd__xor2_2_4/A VPWR VGND VPWR VGND sky130_fd_sc_hd__xor2_2
Xsky130_fd_sc_hd__and3_2_6 sky130_fd_sc_hd__and4_2_0/X sky130_fd_sc_hd__and3_2_6/X sky130_fd_sc_hd__and4_2_1/X sky130_fd_sc_hd__and3_2_6/C VPWR VGND sky130_fd_sc_hd__and4_2_0/VPB VGND sky130_fd_sc_hd__and3_2
Xsky130_fd_sc_hd__o21a_2_15 sky130_fd_sc_hd__or2_2_9/A sky130_fd_sc_hd__o21ai_2_5/Y sky130_fd_sc_hd__o21a_2_15/A2 sky130_fd_sc_hd__o21a_2_15/X VGND VPWR sky130_fd_sc_hd__o31a_2_2/VPB VGND sky130_fd_sc_hd__o21a_2
Xsky130_fd_sc_hd__o21a_2_26 sky130_fd_sc_hd__inv_2_20/A sky130_fd_sc_hd__or4_2_6/X sky130_fd_sc_hd__nor2_2_45/Y sky130_fd_sc_hd__o21a_2_26/X VGND VPWR VPWR VGND sky130_fd_sc_hd__o21a_2
Xsky130_fd_sc_hd__and2_2_16 sky130_fd_sc_hd__or2_2_11/B sky130_fd_sc_hd__or2_2_10/A sky130_fd_sc_hd__and3_2_25/C VPWR VGND sky130_fd_sc_hd__and2_2_16/VPB VGND sky130_fd_sc_hd__and2_2
Xsky130_fd_sc_hd__a32o_2_2 sky130_fd_sc_hd__and4_2_3/A sky130_fd_sc_hd__a32o_2_2/X sky130_fd_sc_hd__inv_2_7/A sky130_fd_sc_hd__and3_2_10/B I sky130_fd_sc_hd__inv_2_10/Y VGND VPWR VPWR VGND sky130_fd_sc_hd__a32o_2
Xsky130_fd_sc_hd__and2b_2_28 sky130_fd_sc_hd__and4_2_5/C sky130_fd_sc_hd__o21a_2_24/A1 sky130_fd_sc_hd__nand4_2_11/C VPWR VGND VPWR VGND sky130_fd_sc_hd__and2b_2
Xsky130_fd_sc_hd__and2b_2_17 sky130_fd_sc_hd__o31a_2_1/A3 sky130_fd_sc_hd__or2_2_9/A sky130_fd_sc_hd__or3b_2_0/A VPWR VGND VPWR VGND sky130_fd_sc_hd__and2b_2
Xsky130_fd_sc_hd__nand2_2_30 sky130_fd_sc_hd__o31a_2_1/B1 sky130_fd_sc_hd__or2_2_9/A sky130_fd_sc_hd__or2_2_8/B VGND VPWR VPWR VGND sky130_fd_sc_hd__nand2_2
Xsky130_fd_sc_hd__dfrtp_2_18 sky130_fd_sc_hd__xor2_2_4/A rst_n sky130_fd_sc_hd__o311a_2_1/X sky130_fd_sc_hd__clkbuf_8_4/X VGND VPWR VPWR VGND sky130_fd_sc_hd__dfrtp_2
Xsky130_fd_sc_hd__dfrtp_2_29 sky130_fd_sc_hd__inv_2_8/A rst_n sky130_fd_sc_hd__dfrtp_2_29/D sky130_fd_sc_hd__clkbuf_8_4/X VGND VPWR VPWR VGND sky130_fd_sc_hd__dfrtp_2
Xsky130_fd_sc_hd__a22o_2_1 sky130_fd_sc_hd__inv_2_7/Y sky130_fd_sc_hd__or2_2_7/A sky130_fd_sc_hd__a22o_2_1/X sky130_fd_sc_hd__inv_2_9/Y sky130_fd_sc_hd__o211a_2_8/X VPWR VGND VPWR VGND sky130_fd_sc_hd__a22o_2
Xsky130_fd_sc_hd__clkbuf_4_10 sky130_fd_sc_hd__clkbuf_4_10/X sky130_fd_sc_hd__clkbuf_8_9/X VGND VPWR VPWR VGND sky130_fd_sc_hd__clkbuf_4
Xsky130_fd_sc_hd__or3_2_2 sky130_fd_sc_hd__or3_2_3/A sky130_fd_sc_hd__or3_2_2/B sky130_fd_sc_hd__or4_2_0/C sky130_fd_sc_hd__or3_2_2/C VGND VPWR VPWR VGND sky130_fd_sc_hd__or3_2
Xsky130_fd_sc_hd__inv_2_6 sky130_fd_sc_hd__inv_2_6/A sky130_fd_sc_hd__inv_2_6/Y VPWR VGND VPWR VGND sky130_fd_sc_hd__inv_2
Xsky130_fd_sc_hd__mux2_1_12 sky130_fd_sc_hd__inv_2_7/A sky130_fd_sc_hd__mux2_1_12/A1 sky130_fd_sc_hd__mux2_1_12/A0 sky130_fd_sc_hd__mux2_1_12/X VGND VPWR VPWR VGND sky130_fd_sc_hd__mux2_1
Xsky130_fd_sc_hd__a311o_2_0 sky130_fd_sc_hd__and3_2_3/B sky130_fd_sc_hd__and3_2_1/X sky130_fd_sc_hd__or3_2_4/B sky130_fd_sc_hd__xor2_2_3/A sky130_fd_sc_hd__or4_2_0/A sky130_fd_sc_hd__or2_2_0/B VGND VPWR VPWR VGND sky130_fd_sc_hd__a311o_2
Xsky130_fd_sc_hd__dfstp_2_0 sky130_fd_sc_hd__xor2_2_17/B sky130_fd_sc_hd__dfstp_2_0/D VPWR rst_n sky130_fd_sc_hd__clkbuf_8_7/X VGND VPWR VGND sky130_fd_sc_hd__dfstp_2
Xsky130_fd_sc_hd__xor2_2_5 sky130_fd_sc_hd__xor2_2_5/X sky130_fd_sc_hd__xor2_2_5/B sky130_fd_sc_hd__xor2_2_5/A VPWR VGND VPWR VGND sky130_fd_sc_hd__xor2_2
Xsky130_fd_sc_hd__and3_2_7 sky130_fd_sc_hd__inv_2_7/A sky130_fd_sc_hd__and3_2_7/X sky130_fd_sc_hd__inv_2_9/A sky130_fd_sc_hd__and3_2_7/C VPWR VGND VPWR VGND sky130_fd_sc_hd__and3_2
Xsky130_fd_sc_hd__o21a_2_16 sky130_fd_sc_hd__o21a_2_16/A1 sky130_fd_sc_hd__a31o_2_17/X sky130_fd_sc_hd__nand4_2_4/Y sky130_fd_sc_hd__o21a_2_16/X VGND VPWR VPWR VGND sky130_fd_sc_hd__o21a_2
Xsky130_fd_sc_hd__o21a_2_27 sky130_fd_sc_hd__o21a_2_27/A1 sky130_fd_sc_hd__a31o_2_22/X sky130_fd_sc_hd__o21a_2_27/A2 sky130_fd_sc_hd__o21a_2_27/X VGND VPWR VPWR VGND sky130_fd_sc_hd__o21a_2
Xsky130_fd_sc_hd__a32o_2_3 sky130_fd_sc_hd__a32o_2_4/B2 sky130_fd_sc_hd__a32o_2_3/X sky130_fd_sc_hd__and2_2_15/X sky130_fd_sc_hd__and4b_2_3/X sky130_fd_sc_hd__inv_2_23/Y sky130_fd_sc_hd__a32o_2_3/B1 VGND VPWR VPWR VGND sky130_fd_sc_hd__a32o_2
Xsky130_fd_sc_hd__clkbuf_16_0 sky130_fd_sc_hd__clkbuf_8_9/A clk VGND VPWR VPWR VGND sky130_fd_sc_hd__clkbuf_16
Xsky130_fd_sc_hd__and2b_2_29 sky130_fd_sc_hd__and3_2_12/A sky130_fd_sc_hd__o21a_2_27/A1 sky130_fd_sc_hd__nand4_2_12/C VPWR VGND VPWR VGND sky130_fd_sc_hd__and2b_2
Xsky130_fd_sc_hd__and2b_2_18 sky130_fd_sc_hd__o32a_2_3/A1 sky130_fd_sc_hd__nor2_2_34/Y sky130_fd_sc_hd__xor2_2_16/X VPWR VGND VPWR VGND sky130_fd_sc_hd__and2b_2
Xsky130_fd_sc_hd__nand2_2_20 sky130_fd_sc_hd__and2_2_8/B sky130_fd_sc_hd__or2_2_9/B sky130_fd_sc_hd__or2_2_8/B VGND VPWR sky130_fd_sc_hd__o22a_2_2/VPB VGND sky130_fd_sc_hd__nand2_2
Xsky130_fd_sc_hd__nand2_2_31 sky130_fd_sc_hd__xor2_2_20/B sky130_fd_sc_hd__nand2_2_31/A sky130_fd_sc_hd__a22o_2_3/X VGND VPWR VPWR VGND sky130_fd_sc_hd__nand2_2
Xsky130_fd_sc_hd__dfrtp_2_19 sky130_fd_sc_hd__nor3_2_2/B rst_n sky130_fd_sc_hd__and2b_2_9/X sky130_fd_sc_hd__clkbuf_8_3/X VGND VPWR VPWR VGND sky130_fd_sc_hd__dfrtp_2
Xsky130_fd_sc_hd__a22o_2_2 sky130_fd_sc_hd__or4_2_4/X sky130_fd_sc_hd__a22o_2_2/A2 sky130_fd_sc_hd__a22o_2_2/X sky130_fd_sc_hd__a22o_2_2/B2 sky130_fd_sc_hd__buf_2_0/X VPWR VGND VPWR VGND sky130_fd_sc_hd__a22o_2
Xsky130_fd_sc_hd__clkbuf_4_11 sky130_fd_sc_hd__clkbuf_4_11/X sky130_fd_sc_hd__clkbuf_8_11/X VGND VPWR VPWR VGND sky130_fd_sc_hd__clkbuf_4
Xsky130_fd_sc_hd__o31a_2_10 sky130_fd_sc_hd__o31a_2_10/X sky130_fd_sc_hd__o31a_2_9/A1 sky130_fd_sc_hd__a22o_2_13/X sky130_fd_sc_hd__or3_2_15/X sky130_fd_sc_hd__a22o_2_17/X VGND VPWR VPWR VGND sky130_fd_sc_hd__o31a_2
Xsky130_fd_sc_hd__or3_2_3 sky130_fd_sc_hd__or3_2_3/A sky130_fd_sc_hd__or3_2_3/B sky130_fd_sc_hd__or3_2_3/X sky130_fd_sc_hd__or3_2_3/C VGND VPWR VPWR VGND sky130_fd_sc_hd__or3_2
Xsky130_fd_sc_hd__inv_2_7 sky130_fd_sc_hd__inv_2_7/A sky130_fd_sc_hd__inv_2_7/Y VPWR VGND VPWR VGND sky130_fd_sc_hd__inv_2
Xsky130_fd_sc_hd__mux2_1_13 sky130_fd_sc_hd__inv_2_7/A I sky130_fd_sc_hd__a22o_2_2/A2 sky130_fd_sc_hd__mux2_1_13/X VGND VPWR VPWR VGND sky130_fd_sc_hd__mux2_1
Xsky130_fd_sc_hd__a311o_2_1 sky130_fd_sc_hd__o31a_2_0/B1 sky130_fd_sc_hd__and3b_2_0/C sky130_fd_sc_hd__and2b_2_6/X sky130_fd_sc_hd__nor3_2_1/C sky130_fd_sc_hd__o32ai_2_0/B1 sky130_fd_sc_hd__nand2b_2_8/Y VGND VPWR VPWR VGND sky130_fd_sc_hd__a311o_2
Xsky130_fd_sc_hd__dfstp_2_1 sky130_fd_sc_hd__xor2_2_16/A sky130_fd_sc_hd__o221a_2_1/X VPWR rst_n sky130_fd_sc_hd__dfxtp_2_3/CLK VGND VPWR VGND sky130_fd_sc_hd__dfstp_2
Xsky130_fd_sc_hd__o31a_2_0 sky130_fd_sc_hd__o31a_2_0/X sky130_fd_sc_hd__o31a_2_0/A1 sky130_fd_sc_hd__o31a_2_0/A2 sky130_fd_sc_hd__o31a_2_0/B1 sky130_fd_sc_hd__nor3_2_1/Y VGND VPWR sky130_fd_sc_hd__o31a_2_0/VPB VGND sky130_fd_sc_hd__o31a_2
Xsky130_fd_sc_hd__xor2_2_6 sky130_fd_sc_hd__or2_2_5/A sky130_fd_sc_hd__xor2_2_6/B sky130_fd_sc_hd__xor2_2_6/A VPWR VGND VPWR VGND sky130_fd_sc_hd__xor2_2
Xsky130_fd_sc_hd__and3_2_8 sky130_fd_sc_hd__and4_2_3/B sky130_fd_sc_hd__and4_2_4/D sky130_fd_sc_hd__and4_2_3/A sky130_fd_sc_hd__or3_2_8/B VPWR VGND VPWR VGND sky130_fd_sc_hd__and3_2
Xsky130_fd_sc_hd__dfrtp_2_0 sky130_fd_sc_hd__nand4_2_0/C rst_n sky130_fd_sc_hd__o21a_2_4/X sky130_fd_sc_hd__clkbuf_8_0/X VGND VPWR sky130_fd_sc_hd__nand4_2_0/VPB VGND sky130_fd_sc_hd__dfrtp_2
Xsky130_fd_sc_hd__o21a_2_28 sky130_fd_sc_hd__o21a_2_28/A1 sky130_fd_sc_hd__a31o_2_23/X sky130_fd_sc_hd__o21a_2_28/A2 sky130_fd_sc_hd__o21a_2_28/X VGND VPWR VPWR VGND sky130_fd_sc_hd__o21a_2
Xsky130_fd_sc_hd__o21a_2_17 sky130_fd_sc_hd__inv_2_16/A sky130_fd_sc_hd__or4_2_5/X sky130_fd_sc_hd__nor2_2_42/Y sky130_fd_sc_hd__o21a_2_17/X VGND VPWR VPWR VGND sky130_fd_sc_hd__o21a_2
Xsky130_fd_sc_hd__a32o_2_4 sky130_fd_sc_hd__a32o_2_4/B2 sky130_fd_sc_hd__a32o_2_4/X sky130_fd_sc_hd__and2_2_15/X sky130_fd_sc_hd__and4b_2_3/X sky130_fd_sc_hd__inv_2_23/A success VGND VPWR VPWR VGND sky130_fd_sc_hd__a32o_2
Xsky130_fd_sc_hd__and2b_2_19 sky130_fd_sc_hd__and2b_2_19/X sky130_fd_sc_hd__o221a_2_2/C1 sky130_fd_sc_hd__or2_2_8/X VPWR VGND VPWR VGND sky130_fd_sc_hd__and2b_2
Xsky130_fd_sc_hd__a22o_2_20 sky130_fd_sc_hd__xnor2_2_13/Y sky130_fd_sc_hd__or3_2_17/B sky130_fd_sc_hd__o31a_2_3/A3 sky130_fd_sc_hd__conb_1_0/LO sky130_fd_sc_hd__nor3b_2_3/Y VPWR VGND VPWR VGND sky130_fd_sc_hd__a22o_2
Xsky130_fd_sc_hd__nand2_2_10 sky130_fd_sc_hd__a31o_2_5/A3 sky130_fd_sc_hd__or4_2_0/A sky130_fd_sc_hd__o31ai_2_1/Y VGND VPWR VPWR VGND sky130_fd_sc_hd__nand2_2
Xsky130_fd_sc_hd__nand2_2_21 sky130_fd_sc_hd__and3_2_2/A sky130_fd_sc_hd__xor2_2_7/A sky130_fd_sc_hd__xor2_2_9/A VGND VPWR VPWR VGND sky130_fd_sc_hd__nand2_2
Xsky130_fd_sc_hd__nand2_2_32 sky130_fd_sc_hd__inv_2_12/A sky130_fd_sc_hd__or2_2_9/B sky130_fd_sc_hd__o31a_2_1/A3 VGND VPWR VPWR VGND sky130_fd_sc_hd__nand2_2
Xsky130_fd_sc_hd__a22o_2_3 sky130_fd_sc_hd__or3_2_9/A sky130_fd_sc_hd__or2_2_9/X sky130_fd_sc_hd__a22o_2_3/X sky130_fd_sc_hd__or3b_2_0/X sky130_fd_sc_hd__o32a_2_2/A2 VPWR VGND VPWR VGND sky130_fd_sc_hd__a22o_2
Xsky130_fd_sc_hd__clkbuf_4_12 sky130_fd_sc_hd__clkbuf_4_12/X sky130_fd_sc_hd__clkbuf_8_10/X VGND VPWR VPWR VGND sky130_fd_sc_hd__clkbuf_4
Xsky130_fd_sc_hd__or3_2_4 sky130_fd_sc_hd__or4_2_0/A sky130_fd_sc_hd__or3_2_4/B sky130_fd_sc_hd__or3_2_4/X sky130_fd_sc_hd__or3_2_4/C VGND VPWR VPWR VGND sky130_fd_sc_hd__or3_2
Xsky130_fd_sc_hd__inv_2_8 sky130_fd_sc_hd__inv_2_8/A sky130_fd_sc_hd__inv_2_8/Y VPWR VGND VPWR VGND sky130_fd_sc_hd__inv_2
Xsky130_fd_sc_hd__mux2_1_14 sky130_fd_sc_hd__inv_2_7/A sky130_fd_sc_hd__mux2_1_15/A0 sky130_fd_sc_hd__mux2_1_8/A1 sky130_fd_sc_hd__mux2_1_14/X VGND VPWR VPWR VGND sky130_fd_sc_hd__mux2_1
Xsky130_fd_sc_hd__dfstp_2_2 sky130_fd_sc_hd__xor2_2_20/A sky130_fd_sc_hd__dfstp_2_2/D VPWR rst_n sky130_fd_sc_hd__clkbuf_8_7/X VGND VPWR VGND sky130_fd_sc_hd__dfstp_2
Xsky130_fd_sc_hd__o31a_2_1 sky130_fd_sc_hd__o31a_2_1/X sky130_fd_sc_hd__or2_2_9/B sky130_fd_sc_hd__or3_2_9/A sky130_fd_sc_hd__o31a_2_1/B1 sky130_fd_sc_hd__o31a_2_1/A3 VGND VPWR VPWR VGND sky130_fd_sc_hd__o31a_2
Xsky130_fd_sc_hd__xor2_2_7 sky130_fd_sc_hd__xor2_2_7/X sky130_fd_sc_hd__xor2_2_9/A sky130_fd_sc_hd__xor2_2_7/A VPWR VGND VPWR VGND sky130_fd_sc_hd__xor2_2
Xsky130_fd_sc_hd__and3_2_9 I sky130_fd_sc_hd__inv_2_10/A sky130_fd_sc_hd__or3_2_8/A sky130_fd_sc_hd__inv_2_7/A VPWR VGND sky130_fd_sc_hd__and3_2_9/VPB VGND sky130_fd_sc_hd__and3_2
Xsky130_fd_sc_hd__dfrtp_2_1 sky130_fd_sc_hd__inv_2_1/A rst_n sky130_fd_sc_hd__o21a_2_7/X sky130_fd_sc_hd__clkbuf_8_0/X VGND VPWR VPWR VGND sky130_fd_sc_hd__dfrtp_2
Xsky130_fd_sc_hd__o21a_2_29 sky130_fd_sc_hd__inv_2_17/A sky130_fd_sc_hd__or4_2_9/X sky130_fd_sc_hd__nor2_2_41/Y sky130_fd_sc_hd__o21a_2_29/X VGND VPWR VPWR VGND sky130_fd_sc_hd__o21a_2
Xsky130_fd_sc_hd__o21a_2_18 sky130_fd_sc_hd__o21a_2_18/A1 sky130_fd_sc_hd__a31o_2_16/X sky130_fd_sc_hd__nand4_2_6/Y sky130_fd_sc_hd__o21a_2_18/X VGND VPWR VPWR VGND sky130_fd_sc_hd__o21a_2
Xsky130_fd_sc_hd__o21a_2_0 sky130_fd_sc_hd__or3_2_3/A sky130_fd_sc_hd__or3_2_3/B sky130_fd_sc_hd__or3_2_3/C sky130_fd_sc_hd__or4_2_0/D VGND VPWR VPWR VGND sky130_fd_sc_hd__o21a_2
Xsky130_fd_sc_hd__a22o_2_21 sky130_fd_sc_hd__o31a_2_2/X sky130_fd_sc_hd__nor3b_2_2/Y sky130_fd_sc_hd__o31a_2_9/A2 sky130_fd_sc_hd__a22o_2_21/B2 sky130_fd_sc_hd__nor3_2_3/Y VPWR VGND VPWR VGND sky130_fd_sc_hd__a22o_2
Xsky130_fd_sc_hd__a22o_2_10 sky130_fd_sc_hd__xnor2_2_14/Y sky130_fd_sc_hd__or3_2_17/B sky130_fd_sc_hd__o31a_2_9/A3 sky130_fd_sc_hd__o21bai_2_0/Y sky130_fd_sc_hd__nor3b_2_3/Y VPWR VGND VPWR VGND sky130_fd_sc_hd__a22o_2
Xsky130_fd_sc_hd__nand2_2_11 sky130_fd_sc_hd__o21a_2_3/A2 sky130_fd_sc_hd__or2_2_4/A sky130_fd_sc_hd__nand2_2_5/Y VGND VPWR VPWR VGND sky130_fd_sc_hd__nand2_2
Xsky130_fd_sc_hd__nand2_2_33 sky130_fd_sc_hd__or4_2_9/D I sky130_fd_sc_hd__inv_2_7/A VGND VPWR VPWR VGND sky130_fd_sc_hd__nand2_2
Xsky130_fd_sc_hd__nand2_2_22 sky130_fd_sc_hd__and3_2_2/B sky130_fd_sc_hd__xor2_2_4/A sky130_fd_sc_hd__xor2_2_7/X VGND VPWR VPWR VGND sky130_fd_sc_hd__nand2_2
Xsky130_fd_sc_hd__a22o_2_4 sky130_fd_sc_hd__inv_2_7/A sky130_fd_sc_hd__xor2_2_20/A sky130_fd_sc_hd__a22o_2_4/X sky130_fd_sc_hd__a22o_2_4/B2 sky130_fd_sc_hd__nor2_2_39/Y VPWR VGND VPWR VGND sky130_fd_sc_hd__a22o_2
Xsky130_fd_sc_hd__nand4_2_0 sky130_fd_sc_hd__inv_2_7/A I sky130_fd_sc_hd__o21a_2_4/A2 sky130_fd_sc_hd__nor4_2_0/Y sky130_fd_sc_hd__nand4_2_0/C VGND VPWR sky130_fd_sc_hd__nand4_2_0/VPB VGND sky130_fd_sc_hd__nand4_2
Xsky130_fd_sc_hd__clkbuf_4_13 sky130_fd_sc_hd__clkbuf_4_13/X sky130_fd_sc_hd__dfxtp_2_2/CLK VGND VPWR sky130_fd_sc_hd__clkbuf_8_12/VPB VGND sky130_fd_sc_hd__clkbuf_4
Xsky130_fd_sc_hd__or3_2_5 sky130_fd_sc_hd__or3_2_5/A sky130_fd_sc_hd__or3_2_5/B sky130_fd_sc_hd__or3_2_5/X sky130_fd_sc_hd__or3_2_5/C VGND VPWR VPWR VGND sky130_fd_sc_hd__or3_2
Xsky130_fd_sc_hd__inv_2_9 sky130_fd_sc_hd__inv_2_9/A sky130_fd_sc_hd__inv_2_9/Y VPWR VGND VPWR VGND sky130_fd_sc_hd__inv_2
Xsky130_fd_sc_hd__and3b_2_0 sky130_fd_sc_hd__and2_2_7/B sky130_fd_sc_hd__xnor2_2_6/A sky130_fd_sc_hd__nor3_2_1/B sky130_fd_sc_hd__and3b_2_0/C VGND VPWR VPWR VGND sky130_fd_sc_hd__and3b_2
Xsky130_fd_sc_hd__nor2_2_0 sky130_fd_sc_hd__nor2_2_0/B sky130_fd_sc_hd__xor2_2_3/B sky130_fd_sc_hd__nor2_2_8/A VGND VPWR VPWR VGND sky130_fd_sc_hd__nor2_2
Xsky130_fd_sc_hd__mux2_1_15 sky130_fd_sc_hd__inv_2_7/A sky130_fd_sc_hd__mux2_1_16/A0 sky130_fd_sc_hd__mux2_1_15/A0 sky130_fd_sc_hd__mux2_1_15/X VGND VPWR VPWR VGND sky130_fd_sc_hd__mux2_1
Xsky130_fd_sc_hd__dfstp_2_3 sky130_fd_sc_hd__or2_2_12/A sky130_fd_sc_hd__o32a_2_3/X VPWR rst_n sky130_fd_sc_hd__clkbuf_8_7/X VGND VPWR VGND sky130_fd_sc_hd__dfstp_2
Xsky130_fd_sc_hd__o31a_2_2 sky130_fd_sc_hd__o31a_2_2/X sky130_fd_sc_hd__o31a_2_2/A1 sky130_fd_sc_hd__o31a_2_2/A2 sky130_fd_sc_hd__inv_2_14/Y sky130_fd_sc_hd__o31a_2_2/A3 VGND VPWR sky130_fd_sc_hd__o31a_2_2/VPB VGND sky130_fd_sc_hd__o31a_2
Xsky130_fd_sc_hd__nor2_2_40 sky130_fd_sc_hd__nor2_2_46/A sky130_fd_sc_hd__nor2_2_40/Y sky130_fd_sc_hd__nor2_2_40/A VGND VPWR VPWR VGND sky130_fd_sc_hd__nor2_2
Xsky130_fd_sc_hd__xor2_2_8 sky130_fd_sc_hd__or4_2_0/A sky130_fd_sc_hd__xor2_2_8/B sky130_fd_sc_hd__xor2_2_8/A VPWR VGND VPWR VGND sky130_fd_sc_hd__xor2_2
Xsky130_fd_sc_hd__dfrtp_2_2 sky130_fd_sc_hd__or4_2_1/A rst_n sky130_fd_sc_hd__a21o_2_0/X sky130_fd_sc_hd__dfrtp_2_8/CLK VGND VPWR VPWR VGND sky130_fd_sc_hd__dfrtp_2
Xsky130_fd_sc_hd__o21a_2_19 sky130_fd_sc_hd__o21a_2_19/A1 sky130_fd_sc_hd__a31o_2_18/X sky130_fd_sc_hd__nand4_2_7/Y sky130_fd_sc_hd__o21a_2_19/X VGND VPWR VPWR VGND sky130_fd_sc_hd__o21a_2
Xsky130_fd_sc_hd__o21a_2_1 sky130_fd_sc_hd__or3_2_3/B sky130_fd_sc_hd__or2_2_4/X sky130_fd_sc_hd__and2_2_2/X sky130_fd_sc_hd__o21a_2_1/X VGND VPWR VPWR VGND sky130_fd_sc_hd__o21a_2
Xsky130_fd_sc_hd__xnor2_2_0 sky130_fd_sc_hd__xor2_2_3/A sky130_fd_sc_hd__xnor2_2_0/A sky130_fd_sc_hd__xor2_2_1/X VGND VPWR VPWR VGND sky130_fd_sc_hd__xnor2_2
Xsky130_fd_sc_hd__a22o_2_11 sky130_fd_sc_hd__xnor2_2_18/Y sky130_fd_sc_hd__or3_2_17/B sky130_fd_sc_hd__o31a_2_6/A3 sky130_fd_sc_hd__o31a_2_0/X sky130_fd_sc_hd__nor3b_2_3/Y VPWR VGND VPWR VGND sky130_fd_sc_hd__a22o_2
Xsky130_fd_sc_hd__a22o_2_22 sky130_fd_sc_hd__or3b_2_0/A sky130_fd_sc_hd__or3_2_9/C sky130_fd_sc_hd__a22o_2_22/X sky130_fd_sc_hd__or2_2_9/B sky130_fd_sc_hd__nand2_2_31/A VPWR VGND VPWR VGND sky130_fd_sc_hd__a22o_2
Xsky130_fd_sc_hd__nand2_2_12 sky130_fd_sc_hd__o311a_2_0/C1 sky130_fd_sc_hd__or4_2_0/A sky130_fd_sc_hd__mux2_1_1/X VGND VPWR VPWR VGND sky130_fd_sc_hd__nand2_2
Xsky130_fd_sc_hd__nand2_2_23 sky130_fd_sc_hd__mux2_1_5/A1 sky130_fd_sc_hd__inv_2_9/A sky130_fd_sc_hd__inv_2_7/A VGND VPWR VPWR VGND sky130_fd_sc_hd__nand2_2
Xsky130_fd_sc_hd__nand2_2_34 sky130_fd_sc_hd__or4_2_5/D I sky130_fd_sc_hd__inv_2_7/A VGND VPWR VPWR VGND sky130_fd_sc_hd__nand2_2
Xsky130_fd_sc_hd__a22o_2_5 sky130_fd_sc_hd__inv_2_7/A sky130_fd_sc_hd__xor2_2_14/B sky130_fd_sc_hd__a22o_2_5/X sky130_fd_sc_hd__nor2_2_39/Y sky130_fd_sc_hd__xor2_2_20/A VPWR VGND VPWR VGND sky130_fd_sc_hd__a22o_2
Xsky130_fd_sc_hd__nand4_2_1 sky130_fd_sc_hd__inv_2_7/A I sky130_fd_sc_hd__nand4_2_1/Y sky130_fd_sc_hd__nand4_2_1/D sky130_fd_sc_hd__nand4_2_1/C VGND VPWR VPWR VGND sky130_fd_sc_hd__nand4_2
Xsky130_fd_sc_hd__clkbuf_4_14 sky130_fd_sc_hd__clkbuf_4_14/X sky130_fd_sc_hd__dfrtp_2_8/CLK VGND VPWR VPWR VGND sky130_fd_sc_hd__clkbuf_4
Xsky130_fd_sc_hd__a21o_2_10 sky130_fd_sc_hd__a21o_2_10/X sky130_fd_sc_hd__and4_2_3/B sky130_fd_sc_hd__and4_2_3/A sky130_fd_sc_hd__inv_2_10/A VGND VPWR VPWR VGND sky130_fd_sc_hd__a21o_2
Xsky130_fd_sc_hd__or3_2_6 sky130_fd_sc_hd__or3_2_6/A sky130_fd_sc_hd__or3_2_6/B sky130_fd_sc_hd__or3_2_6/X sky130_fd_sc_hd__or3_2_6/C VGND VPWR VPWR VGND sky130_fd_sc_hd__or3_2
Xsky130_fd_sc_hd__and3b_2_1 sky130_fd_sc_hd__or2_2_9/B sky130_fd_sc_hd__and3b_2_1/X sky130_fd_sc_hd__or2_2_8/B sky130_fd_sc_hd__or2_2_9/A VGND VPWR VPWR VGND sky130_fd_sc_hd__and3b_2
Xsky130_fd_sc_hd__nor2_2_1 sky130_fd_sc_hd__or2_2_0/B sky130_fd_sc_hd__or3_2_2/B sky130_fd_sc_hd__nor2_2_4/Y VGND VPWR VPWR VGND sky130_fd_sc_hd__nor2_2
Xsky130_fd_sc_hd__mux2_1_16 sky130_fd_sc_hd__inv_2_7/A sky130_fd_sc_hd__mux2_1_9/A0 sky130_fd_sc_hd__mux2_1_16/A0 sky130_fd_sc_hd__mux2_1_16/X VGND VPWR VPWR VGND sky130_fd_sc_hd__mux2_1
Xsky130_fd_sc_hd__nand2b_2_20 sky130_fd_sc_hd__o21a_2_27/A2 sky130_fd_sc_hd__dfrtp_2_70/D sky130_fd_sc_hd__o21a_2_27/A1 VGND VPWR VPWR VGND sky130_fd_sc_hd__nand2b_2
Xsky130_fd_sc_hd__o31a_2_3 sky130_fd_sc_hd__o31a_2_3/X sky130_fd_sc_hd__o31a_2_9/A1 sky130_fd_sc_hd__a22o_2_6/X sky130_fd_sc_hd__or3_2_13/X sky130_fd_sc_hd__o31a_2_3/A3 VGND VPWR VPWR VGND sky130_fd_sc_hd__o31a_2
Xsky130_fd_sc_hd__nor2_2_41 sky130_fd_sc_hd__or4_2_9/D sky130_fd_sc_hd__nor2_2_41/Y sky130_fd_sc_hd__or4_2_9/C VGND VPWR VPWR VGND sky130_fd_sc_hd__nor2_2
Xsky130_fd_sc_hd__nor2_2_30 sky130_fd_sc_hd__nor2_2_30/B sky130_fd_sc_hd__nor2_2_30/Y sky130_fd_sc_hd__inv_2_10/A VGND VPWR VPWR VGND sky130_fd_sc_hd__nor2_2
Xsky130_fd_sc_hd__xor2_2_9 sky130_fd_sc_hd__xor2_2_9/X sky130_fd_sc_hd__inv_2_5/A sky130_fd_sc_hd__xor2_2_9/A VPWR VGND VPWR VGND sky130_fd_sc_hd__xor2_2
Xsky130_fd_sc_hd__and2_2_0 sky130_fd_sc_hd__or2_2_1/X sky130_fd_sc_hd__and3_2_0/C sky130_fd_sc_hd__or2_2_0/B VPWR VGND VPWR VGND sky130_fd_sc_hd__and2_2
Xsky130_fd_sc_hd__dfrtp_2_3 sky130_fd_sc_hd__or4_2_3/A rst_n sky130_fd_sc_hd__a21o_2_2/X sky130_fd_sc_hd__clkbuf_8_0/X VGND VPWR VPWR VGND sky130_fd_sc_hd__dfrtp_2
Xsky130_fd_sc_hd__o21a_2_2 sky130_fd_sc_hd__or3_2_3/B sky130_fd_sc_hd__or2_2_4/B sky130_fd_sc_hd__inv_2_4/A sky130_fd_sc_hd__or2_2_6/B VGND VPWR VPWR VGND sky130_fd_sc_hd__o21a_2
Xsky130_fd_sc_hd__xnor2_2_1 sky130_fd_sc_hd__nor2_2_8/A sky130_fd_sc_hd__or4_2_4/B sky130_fd_sc_hd__xor2_2_0/X VGND VPWR VPWR VGND sky130_fd_sc_hd__xnor2_2
Xsky130_fd_sc_hd__a22o_2_12 sky130_fd_sc_hd__conb_1_4/LO sky130_fd_sc_hd__nor3b_2_2/Y sky130_fd_sc_hd__o31a_2_5/A2 sky130_fd_sc_hd__o211a_2_9/X sky130_fd_sc_hd__nor3_2_3/Y VPWR VGND VPWR VGND sky130_fd_sc_hd__a22o_2
Xsky130_fd_sc_hd__nand2_2_35 sky130_fd_sc_hd__or4_2_6/D I sky130_fd_sc_hd__inv_2_7/A VGND VPWR VPWR VGND sky130_fd_sc_hd__nand2_2
Xsky130_fd_sc_hd__nand2_2_24 sky130_fd_sc_hd__xnor2_2_11/B sky130_fd_sc_hd__inv_2_10/A sky130_fd_sc_hd__and4_2_4/D VGND VPWR VPWR VGND sky130_fd_sc_hd__nand2_2
Xsky130_fd_sc_hd__nand2_2_13 sky130_fd_sc_hd__or4_2_3/D I sky130_fd_sc_hd__inv_2_7/A VGND VPWR VPWR VGND sky130_fd_sc_hd__nand2_2
Xsky130_fd_sc_hd__nor4b_2_0 sky130_fd_sc_hd__or2_2_8/B sky130_fd_sc_hd__or3_2_6/C sky130_fd_sc_hd__or2_2_9/B sky130_fd_sc_hd__or3b_2_0/A sky130_fd_sc_hd__or2_2_9/A VGND VPWR VPWR VGND sky130_fd_sc_hd__nor4b_2
Xsky130_fd_sc_hd__a22o_2_6 sky130_fd_sc_hd__conb_1_5/LO sky130_fd_sc_hd__nor3b_2_2/Y sky130_fd_sc_hd__a22o_2_6/X sky130_fd_sc_hd__conb_1_3/LO sky130_fd_sc_hd__nor3_2_3/Y VPWR VGND VPWR VGND sky130_fd_sc_hd__a22o_2
Xsky130_fd_sc_hd__nand4_2_2 sky130_fd_sc_hd__inv_2_7/A I sky130_fd_sc_hd__o21a_2_8/A2 sky130_fd_sc_hd__nand4_2_2/D sky130_fd_sc_hd__nand4_2_2/C VGND VPWR VPWR VGND sky130_fd_sc_hd__nand4_2
Xsky130_fd_sc_hd__a21o_2_11 sky130_fd_sc_hd__dfstp_2_2/D sky130_fd_sc_hd__a22o_2_5/X sky130_fd_sc_hd__and2b_2_16/X sky130_fd_sc_hd__xnor2_2_19/Y VGND VPWR VPWR VGND sky130_fd_sc_hd__a21o_2
Xsky130_fd_sc_hd__or3_2_7 sky130_fd_sc_hd__or3_2_7/A sky130_fd_sc_hd__or3_2_7/B sky130_fd_sc_hd__or3_2_7/X sky130_fd_sc_hd__or3_2_7/C VGND VPWR VPWR VGND sky130_fd_sc_hd__or3_2
Xsky130_fd_sc_hd__and3b_2_2 sky130_fd_sc_hd__nor2_2_32/B sky130_fd_sc_hd__and3b_2_2/X sky130_fd_sc_hd__or2_2_8/B sky130_fd_sc_hd__or2_2_9/B VGND VPWR VPWR VGND sky130_fd_sc_hd__and3b_2
Xsky130_fd_sc_hd__nor2_2_2 sky130_fd_sc_hd__inv_2_4/A sky130_fd_sc_hd__or3_2_2/C sky130_fd_sc_hd__or3_2_0/B VGND VPWR VPWR VGND sky130_fd_sc_hd__nor2_2
Xsky130_fd_sc_hd__mux2_1_17 sky130_fd_sc_hd__inv_2_7/A sky130_fd_sc_hd__mux2_1_19/A0 sky130_fd_sc_hd__mux2_1_9/A1 sky130_fd_sc_hd__mux2_1_17/X VGND VPWR VPWR VGND sky130_fd_sc_hd__mux2_1
Xsky130_fd_sc_hd__nand2b_2_21 sky130_fd_sc_hd__o21a_2_28/A2 sky130_fd_sc_hd__dfrtp_2_64/D sky130_fd_sc_hd__o21a_2_28/A1 VGND VPWR VPWR VGND sky130_fd_sc_hd__nand2b_2
Xsky130_fd_sc_hd__nand2b_2_10 sky130_fd_sc_hd__or2_2_9/B sky130_fd_sc_hd__and2_2_7/B sky130_fd_sc_hd__or3b_2_0/A VGND VPWR VPWR VGND sky130_fd_sc_hd__nand2b_2
Xsky130_fd_sc_hd__o31a_2_4 sky130_fd_sc_hd__o31a_2_4/X sky130_fd_sc_hd__o31a_2_9/A1 sky130_fd_sc_hd__a22o_2_7/X sky130_fd_sc_hd__or3_2_12/X sky130_fd_sc_hd__a22o_2_9/X VGND VPWR VPWR VGND sky130_fd_sc_hd__o31a_2
Xsky130_fd_sc_hd__nor2_2_20 sky130_fd_sc_hd__o211a_2_0/X sky130_fd_sc_hd__nor2_2_20/Y sky130_fd_sc_hd__nor2_2_20/A VGND VPWR sky130_fd_sc_hd__and3_2_3/VPB VGND sky130_fd_sc_hd__nor2_2
Xsky130_fd_sc_hd__nor2_2_31 sky130_fd_sc_hd__nor2_2_31/B sky130_fd_sc_hd__nor2_2_31/Y sky130_fd_sc_hd__inv_2_9/A VGND VPWR VPWR VGND sky130_fd_sc_hd__nor2_2
Xsky130_fd_sc_hd__nor2_2_42 sky130_fd_sc_hd__or4_2_5/D sky130_fd_sc_hd__nor2_2_42/Y sky130_fd_sc_hd__or4_2_5/C VGND VPWR VPWR VGND sky130_fd_sc_hd__nor2_2
Xsky130_fd_sc_hd__and2_2_1 sky130_fd_sc_hd__or4_2_4/A sky130_fd_sc_hd__or2_2_1/A sky130_fd_sc_hd__xor2_2_7/A VPWR VGND VPWR VGND sky130_fd_sc_hd__and2_2
Xsky130_fd_sc_hd__dfrtp_2_4 sky130_fd_sc_hd__o21a_2_5/A1 rst_n sky130_fd_sc_hd__dfrtp_2_4/D sky130_fd_sc_hd__dfrtp_2_8/CLK VGND VPWR VPWR VGND sky130_fd_sc_hd__dfrtp_2
Xsky130_fd_sc_hd__o21a_2_3 sky130_fd_sc_hd__or3_2_3/A sky130_fd_sc_hd__or2_2_3/X sky130_fd_sc_hd__o21a_2_3/A2 sky130_fd_sc_hd__o21a_2_3/X VGND VPWR VPWR VGND sky130_fd_sc_hd__o21a_2
Xsky130_fd_sc_hd__xnor2_2_2 sky130_fd_sc_hd__or3_2_0/B sky130_fd_sc_hd__xor2_2_3/A sky130_fd_sc_hd__xor2_2_3/B VGND VPWR VPWR VGND sky130_fd_sc_hd__xnor2_2
Xsky130_fd_sc_hd__a22o_2_13 sky130_fd_sc_hd__a22o_2_13/A1 sky130_fd_sc_hd__nor3b_2_2/Y sky130_fd_sc_hd__a22o_2_13/X sky130_fd_sc_hd__o221a_2_2/X sky130_fd_sc_hd__nor3_2_3/Y VPWR VGND VPWR VGND sky130_fd_sc_hd__a22o_2
Xsky130_fd_sc_hd__nand2_2_36 sky130_fd_sc_hd__or4_2_7/D I sky130_fd_sc_hd__inv_2_7/A VGND VPWR VPWR VGND sky130_fd_sc_hd__nand2_2
Xsky130_fd_sc_hd__nor4b_2_1 sky130_fd_sc_hd__nor3_2_2/Y sky130_fd_sc_hd__or4b_2_8/A sky130_fd_sc_hd__and4_2_3/C sky130_fd_sc_hd__and4_2_3/A sky130_fd_sc_hd__and4_2_3/B VGND VPWR VPWR VGND sky130_fd_sc_hd__nor4b_2
Xsky130_fd_sc_hd__nand2_2_14 sky130_fd_sc_hd__or4_2_1/D I sky130_fd_sc_hd__inv_2_7/A VGND VPWR VPWR VGND sky130_fd_sc_hd__nand2_2
Xsky130_fd_sc_hd__nand2_2_25 sky130_fd_sc_hd__mux2_1_7/A0 sky130_fd_sc_hd__or2_2_7/A I VGND VPWR sky130_fd_sc_hd__nand2_2_25/VPB VGND sky130_fd_sc_hd__nand2_2
Xsky130_fd_sc_hd__a22o_2_7 sky130_fd_sc_hd__a22o_2_7/A1 sky130_fd_sc_hd__nor3b_2_2/Y sky130_fd_sc_hd__a22o_2_7/X sky130_fd_sc_hd__o21a_2_15/X sky130_fd_sc_hd__nor3_2_3/Y VPWR VGND VPWR VGND sky130_fd_sc_hd__a22o_2
Xsky130_fd_sc_hd__nand4_2_3 sky130_fd_sc_hd__inv_2_7/A I sky130_fd_sc_hd__o21a_2_5/A2 sky130_fd_sc_hd__nand4_2_3/D sky130_fd_sc_hd__nand4_2_3/C VGND VPWR VPWR VGND sky130_fd_sc_hd__nand4_2
Xsky130_fd_sc_hd__a21o_2_12 sky130_fd_sc_hd__o32a_2_3/A3 sky130_fd_sc_hd__nor2_2_39/Y sky130_fd_sc_hd__inv_2_7/A sky130_fd_sc_hd__xor2_2_19/B VGND VPWR VPWR VGND sky130_fd_sc_hd__a21o_2
Xsky130_fd_sc_hd__or3_2_8 sky130_fd_sc_hd__or3_2_8/A sky130_fd_sc_hd__or3_2_8/B sky130_fd_sc_hd__or3_2_8/X sky130_fd_sc_hd__or3_2_8/C VGND VPWR VPWR VGND sky130_fd_sc_hd__or3_2
Xsky130_fd_sc_hd__and3b_2_3 sky130_fd_sc_hd__nor2_2_40/A sky130_fd_sc_hd__o32a_2_3/A2 sky130_fd_sc_hd__inv_2_7/A sky130_fd_sc_hd__xor2_2_16/X VGND VPWR VPWR VGND sky130_fd_sc_hd__and3b_2
Xsky130_fd_sc_hd__nor2_2_3 sky130_fd_sc_hd__nor2_2_3/B sky130_fd_sc_hd__nor2_2_3/Y sky130_fd_sc_hd__or3_2_3/B VGND VPWR VPWR VGND sky130_fd_sc_hd__nor2_2
Xsky130_fd_sc_hd__mux2_1_18 sky130_fd_sc_hd__inv_2_7/A sky130_fd_sc_hd__a22o_2_2/A2 sky130_fd_sc_hd__mux2_1_19/A1 sky130_fd_sc_hd__mux2_1_18/X VGND VPWR VPWR VGND sky130_fd_sc_hd__mux2_1
Xsky130_fd_sc_hd__nand2b_2_22 sky130_fd_sc_hd__or2_2_10/A sky130_fd_sc_hd__nor2_2_46/A sky130_fd_sc_hd__inv_2_7/A VGND VPWR VPWR VGND sky130_fd_sc_hd__nand2b_2
Xsky130_fd_sc_hd__nand2b_2_11 sky130_fd_sc_hd__or3b_2_0/A sky130_fd_sc_hd__nand2_2_31/A sky130_fd_sc_hd__or2_2_9/A VGND VPWR VPWR VGND sky130_fd_sc_hd__nand2b_2
Xsky130_fd_sc_hd__o31a_2_5 sky130_fd_sc_hd__o31a_2_5/X sky130_fd_sc_hd__o31a_2_9/A1 sky130_fd_sc_hd__o31a_2_5/A2 sky130_fd_sc_hd__or3_2_17/X sky130_fd_sc_hd__a22o_2_8/X VGND VPWR VPWR VGND sky130_fd_sc_hd__o31a_2
Xsky130_fd_sc_hd__conb_1_0 sky130_fd_sc_hd__conb_1_0/LO sky130_fd_sc_hd__conb_1_0/HI VGND VPWR sky130_fd_sc_hd__o31a_2_0/VPB VGND sky130_fd_sc_hd__conb_1
Xsky130_fd_sc_hd__nor2_2_10 sky130_fd_sc_hd__or3_2_2/B sky130_fd_sc_hd__nor2_2_3/B sky130_fd_sc_hd__or3_2_0/B VGND VPWR VPWR VGND sky130_fd_sc_hd__nor2_2
Xsky130_fd_sc_hd__nor2_2_21 sky130_fd_sc_hd__and3_2_4/X sky130_fd_sc_hd__xor2_2_8/B sky130_fd_sc_hd__nor2_2_21/A VGND VPWR VPWR VGND sky130_fd_sc_hd__nor2_2
Xsky130_fd_sc_hd__nor2_2_32 sky130_fd_sc_hd__nor2_2_32/B sky130_fd_sc_hd__nor2_2_32/Y sky130_fd_sc_hd__or2_2_8/B VGND VPWR VPWR VGND sky130_fd_sc_hd__nor2_2
Xsky130_fd_sc_hd__nor2_2_43 sky130_fd_sc_hd__or4_2_7/D sky130_fd_sc_hd__nor2_2_43/Y sky130_fd_sc_hd__or4_2_7/C VGND VPWR VPWR VGND sky130_fd_sc_hd__nor2_2
Xsky130_fd_sc_hd__and2_2_2 sky130_fd_sc_hd__and2_2_2/A sky130_fd_sc_hd__and2_2_2/X sky130_fd_sc_hd__and3_2_1/C VPWR VGND VPWR VGND sky130_fd_sc_hd__and2_2
Xsky130_fd_sc_hd__dfrtp_2_5 sky130_fd_sc_hd__nand4_2_2/C rst_n sky130_fd_sc_hd__o21a_2_8/X sky130_fd_sc_hd__clkbuf_8_1/X VGND VPWR sky130_fd_sc_hd__dfrtp_2_5/VPB VGND sky130_fd_sc_hd__dfrtp_2
Xsky130_fd_sc_hd__o21a_2_4 sky130_fd_sc_hd__o21a_2_4/A1 sky130_fd_sc_hd__a31o_2_1/X sky130_fd_sc_hd__o21a_2_4/A2 sky130_fd_sc_hd__o21a_2_4/X VGND VPWR VPWR VGND sky130_fd_sc_hd__o21a_2
Xsky130_fd_sc_hd__xnor2_2_3 sky130_fd_sc_hd__and3_2_2/C sky130_fd_sc_hd__xor2_2_0/B sky130_fd_sc_hd__xor2_2_4/A VGND VPWR VPWR VGND sky130_fd_sc_hd__xnor2_2
Xsky130_fd_sc_hd__a22o_2_14 sky130_fd_sc_hd__and3_2_17/X sky130_fd_sc_hd__nor3b_2_2/Y sky130_fd_sc_hd__o31a_2_8/A2 sky130_fd_sc_hd__and3b_2_2/X sky130_fd_sc_hd__nor3_2_3/Y VPWR VGND VPWR VGND sky130_fd_sc_hd__a22o_2
Xsky130_fd_sc_hd__nand2_2_26 sky130_fd_sc_hd__o21a_2_12/A1 sky130_fd_sc_hd__and4_2_3/C sky130_fd_sc_hd__nor3_2_2/A VGND VPWR VPWR VGND sky130_fd_sc_hd__nand2_2
Xsky130_fd_sc_hd__nand2_2_15 sky130_fd_sc_hd__or4_2_2/D I sky130_fd_sc_hd__inv_2_7/A VGND VPWR VPWR VGND sky130_fd_sc_hd__nand2_2
Xsky130_fd_sc_hd__nand2_2_37 sky130_fd_sc_hd__or4_2_8/D I sky130_fd_sc_hd__inv_2_7/A VGND VPWR VPWR VGND sky130_fd_sc_hd__nand2_2
Xsky130_fd_sc_hd__a22o_2_8 sky130_fd_sc_hd__xor2_2_12/X sky130_fd_sc_hd__or3_2_17/B sky130_fd_sc_hd__a22o_2_8/X sky130_fd_sc_hd__o32ai_2_0/Y sky130_fd_sc_hd__nor3b_2_3/Y VPWR VGND VPWR VGND sky130_fd_sc_hd__a22o_2
Xsky130_fd_sc_hd__nand4_2_4 sky130_fd_sc_hd__inv_2_7/A I sky130_fd_sc_hd__nand4_2_4/Y sky130_fd_sc_hd__nand4_2_4/D sky130_fd_sc_hd__nand4_2_4/C VGND VPWR VPWR VGND sky130_fd_sc_hd__nand4_2
Xsky130_fd_sc_hd__a21o_2_13 sky130_fd_sc_hd__a21o_2_13/X sky130_fd_sc_hd__or4_2_5/A sky130_fd_sc_hd__inv_2_16/A sky130_fd_sc_hd__nor2_2_42/Y VGND VPWR VPWR VGND sky130_fd_sc_hd__a21o_2
Xsky130_fd_sc_hd__or3_2_9 sky130_fd_sc_hd__or3_2_9/A sky130_fd_sc_hd__or3_2_9/B sky130_fd_sc_hd__or3_2_9/X sky130_fd_sc_hd__or3_2_9/C VGND VPWR VPWR VGND sky130_fd_sc_hd__or3_2
Xsky130_fd_sc_hd__nor2_2_4 sky130_fd_sc_hd__or2_2_1/B sky130_fd_sc_hd__nor2_2_4/Y sky130_fd_sc_hd__or2_2_1/A VGND VPWR VPWR VGND sky130_fd_sc_hd__nor2_2
Xsky130_fd_sc_hd__mux2_1_19 sky130_fd_sc_hd__inv_2_7/A sky130_fd_sc_hd__mux2_1_19/A1 sky130_fd_sc_hd__mux2_1_19/A0 sky130_fd_sc_hd__mux2_1_19/X VGND VPWR VPWR VGND sky130_fd_sc_hd__mux2_1
Xsky130_fd_sc_hd__nand2b_2_23 sky130_fd_sc_hd__or2_2_11/A sky130_fd_sc_hd__a32o_2_4/B2 sky130_fd_sc_hd__or2_2_11/B VGND VPWR VPWR VGND sky130_fd_sc_hd__nand2b_2
Xsky130_fd_sc_hd__nand2b_2_12 sky130_fd_sc_hd__or2_2_9/A sky130_fd_sc_hd__o221a_2_2/C1 sky130_fd_sc_hd__or3b_2_0/A VGND VPWR VPWR VGND sky130_fd_sc_hd__nand2b_2
Xsky130_fd_sc_hd__o31a_2_6 sky130_fd_sc_hd__o31a_2_6/X sky130_fd_sc_hd__o31a_2_9/A1 sky130_fd_sc_hd__o31a_2_6/A2 sky130_fd_sc_hd__or3_2_10/X sky130_fd_sc_hd__o31a_2_6/A3 VGND VPWR VPWR VGND sky130_fd_sc_hd__o31a_2
Xsky130_fd_sc_hd__conb_1_1 sky130_fd_sc_hd__or3_2_13/A sky130_fd_sc_hd__conb_1_1/HI VGND VPWR sky130_fd_sc_hd__conb_1_1/VPB VGND sky130_fd_sc_hd__conb_1
Xsky130_fd_sc_hd__nor2_2_11 sky130_fd_sc_hd__or2_2_4/B sky130_fd_sc_hd__or3_2_1/C sky130_fd_sc_hd__or3_2_3/B VGND VPWR VPWR VGND sky130_fd_sc_hd__nor2_2
Xsky130_fd_sc_hd__nor2_2_22 sky130_fd_sc_hd__or2_2_9/A sky130_fd_sc_hd__nor3_2_1/B sky130_fd_sc_hd__or3b_2_0/A VGND VPWR VPWR VGND sky130_fd_sc_hd__nor2_2
Xsky130_fd_sc_hd__nor2_2_44 sky130_fd_sc_hd__or4_2_8/D sky130_fd_sc_hd__nor2_2_44/Y sky130_fd_sc_hd__or4_2_8/C VGND VPWR VPWR VGND sky130_fd_sc_hd__nor2_2
Xsky130_fd_sc_hd__nor2_2_33 sky130_fd_sc_hd__or2_2_9/A sky130_fd_sc_hd__nor2_2_33/Y sky130_fd_sc_hd__or3b_2_0/A VGND VPWR VPWR VGND sky130_fd_sc_hd__nor2_2
Xsky130_fd_sc_hd__o211a_2_10 sky130_fd_sc_hd__or2_2_9/A sky130_fd_sc_hd__inv_2_14/Y sky130_fd_sc_hd__or2_2_9/B sky130_fd_sc_hd__inv_2_15/Y sky130_fd_sc_hd__o211a_2_10/X VPWR VGND VPWR VGND sky130_fd_sc_hd__o211a_2
Xsky130_fd_sc_hd__and2_2_3 sky130_fd_sc_hd__or4_2_1/A sky130_fd_sc_hd__and4_2_0/A sky130_fd_sc_hd__or4_2_1/B VPWR VGND VPWR VGND sky130_fd_sc_hd__and2_2
Xsky130_fd_sc_hd__dfrtp_2_6 sky130_fd_sc_hd__nand4_2_1/C rst_n sky130_fd_sc_hd__o21a_2_10/X sky130_fd_sc_hd__clkbuf_8_1/X VGND VPWR VPWR VGND sky130_fd_sc_hd__dfrtp_2
Xsky130_fd_sc_hd__o21a_2_5 sky130_fd_sc_hd__o21a_2_5/A1 sky130_fd_sc_hd__a31o_2_4/X sky130_fd_sc_hd__o21a_2_5/A2 sky130_fd_sc_hd__o21a_2_5/X VGND VPWR VPWR VGND sky130_fd_sc_hd__o21a_2
Xsky130_fd_sc_hd__xnor2_2_4 sky130_fd_sc_hd__xnor2_2_5/B sky130_fd_sc_hd__xnor2_2_4/A sky130_fd_sc_hd__xor2_2_4/X VGND VPWR VPWR VGND sky130_fd_sc_hd__xnor2_2
Xsky130_fd_sc_hd__a22o_2_15 sky130_fd_sc_hd__o21a_2_13/X sky130_fd_sc_hd__nor3b_2_2/Y sky130_fd_sc_hd__o31a_2_6/A2 sky130_fd_sc_hd__and3b_2_1/X sky130_fd_sc_hd__nor3_2_3/Y VPWR VGND VPWR VGND sky130_fd_sc_hd__a22o_2
Xsky130_fd_sc_hd__nand2_2_16 sky130_fd_sc_hd__and3_2_4/B sky130_fd_sc_hd__or4_2_4/D sky130_fd_sc_hd__xnor2_2_5/B VGND VPWR VPWR VGND sky130_fd_sc_hd__nand2_2
Xsky130_fd_sc_hd__nand2_2_27 sky130_fd_sc_hd__o21a_2_15/A2 sky130_fd_sc_hd__or3b_2_0/A sky130_fd_sc_hd__or2_2_8/X VGND VPWR VPWR VGND sky130_fd_sc_hd__nand2_2
Xsky130_fd_sc_hd__nand2_2_38 sky130_fd_sc_hd__nand2_2_38/Y sky130_fd_sc_hd__or2_2_12/A sky130_fd_sc_hd__or2_2_12/B VGND VPWR VPWR VGND sky130_fd_sc_hd__nand2_2
Xsky130_fd_sc_hd__a22o_2_9 sky130_fd_sc_hd__a22o_2_9/A1 sky130_fd_sc_hd__or3_2_17/B sky130_fd_sc_hd__a22o_2_9/X sky130_fd_sc_hd__o22a_2_2/X sky130_fd_sc_hd__nor3b_2_3/Y VPWR VGND VPWR VGND sky130_fd_sc_hd__a22o_2
Xsky130_fd_sc_hd__nand4_2_5 sky130_fd_sc_hd__inv_2_7/A I sky130_fd_sc_hd__nand4_2_5/Y sky130_fd_sc_hd__nand4_2_5/D sky130_fd_sc_hd__nand4_2_5/C VGND VPWR sky130_fd_sc_hd__nand4_2_5/VPB VGND sky130_fd_sc_hd__nand4_2
Xsky130_fd_sc_hd__a21o_2_14 sky130_fd_sc_hd__a21o_2_14/X sky130_fd_sc_hd__or4_2_7/A sky130_fd_sc_hd__inv_2_18/A sky130_fd_sc_hd__nor2_2_43/Y VGND VPWR VPWR VGND sky130_fd_sc_hd__a21o_2
Xsky130_fd_sc_hd__nor2_2_5 sky130_fd_sc_hd__or3_2_3/B sky130_fd_sc_hd__nor2_2_5/Y sky130_fd_sc_hd__nor2_2_5/A VGND VPWR VPWR VGND sky130_fd_sc_hd__nor2_2
Xsky130_fd_sc_hd__nand2b_2_13 sky130_fd_sc_hd__nand4_2_6/Y sky130_fd_sc_hd__dfrtp_2_58/D sky130_fd_sc_hd__o21a_2_18/A1 VGND VPWR VPWR VGND sky130_fd_sc_hd__nand2b_2
Xsky130_fd_sc_hd__o31a_2_7 sky130_fd_sc_hd__o31a_2_7/X sky130_fd_sc_hd__o31a_2_9/A1 sky130_fd_sc_hd__o31a_2_7/A2 sky130_fd_sc_hd__or3_2_11/X sky130_fd_sc_hd__o31a_2_7/A3 VGND VPWR VPWR VGND sky130_fd_sc_hd__o31a_2
Xsky130_fd_sc_hd__conb_1_2 sky130_fd_sc_hd__conb_1_2/LO sky130_fd_sc_hd__conb_1_2/HI VGND VPWR VPWR VGND sky130_fd_sc_hd__conb_1
Xsky130_fd_sc_hd__nor2_2_12 sky130_fd_sc_hd__nor2_2_3/B sky130_fd_sc_hd__or3_2_4/B sky130_fd_sc_hd__or2_2_4/A VGND VPWR VPWR VGND sky130_fd_sc_hd__nor2_2
Xsky130_fd_sc_hd__nor2_2_23 sky130_fd_sc_hd__and2_2_8/A sky130_fd_sc_hd__nor2_2_23/Y sky130_fd_sc_hd__or2_2_8/B VGND VPWR sky130_fd_sc_hd__o22a_2_2/VPB VGND sky130_fd_sc_hd__nor2_2
Xsky130_fd_sc_hd__nor2_2_45 sky130_fd_sc_hd__or4_2_6/D sky130_fd_sc_hd__nor2_2_45/Y sky130_fd_sc_hd__or4_2_6/C VGND VPWR VPWR VGND sky130_fd_sc_hd__nor2_2
Xsky130_fd_sc_hd__nor2_2_34 sky130_fd_sc_hd__nor2_2_40/A sky130_fd_sc_hd__nor2_2_34/Y sky130_fd_sc_hd__inv_2_7/A VGND VPWR sky130_fd_sc_hd__nor2_2_34/VPB VGND sky130_fd_sc_hd__nor2_2
Xsky130_fd_sc_hd__o211a_2_11 sky130_fd_sc_hd__or2_2_11/B sky130_fd_sc_hd__a21o_2_17/X sky130_fd_sc_hd__nand3_2_1/Y sky130_fd_sc_hd__or2_2_8/B sky130_fd_sc_hd__dfxtp_2_3/D VPWR VGND VPWR VGND sky130_fd_sc_hd__o211a_2
Xsky130_fd_sc_hd__and2_2_4 sky130_fd_sc_hd__or4_2_2/A sky130_fd_sc_hd__and4_2_1/B sky130_fd_sc_hd__or4_2_2/B VPWR VGND VPWR VGND sky130_fd_sc_hd__and2_2
Xsky130_fd_sc_hd__dfrtp_2_7 sky130_fd_sc_hd__inv_2_2/A rst_n sky130_fd_sc_hd__o21a_2_9/X sky130_fd_sc_hd__clkbuf_8_1/X VGND VPWR VPWR VGND sky130_fd_sc_hd__dfrtp_2
Xsky130_fd_sc_hd__o21a_2_6 sky130_fd_sc_hd__inv_2_3/A sky130_fd_sc_hd__or4_2_3/X sky130_fd_sc_hd__o21a_2_6/A2 sky130_fd_sc_hd__o21a_2_6/X VGND VPWR VPWR VGND sky130_fd_sc_hd__o21a_2
Xsky130_fd_sc_hd__xnor2_2_5 sky130_fd_sc_hd__xnor2_2_8/A sky130_fd_sc_hd__or4_2_4/D sky130_fd_sc_hd__xnor2_2_5/B VGND VPWR VPWR VGND sky130_fd_sc_hd__xnor2_2
Xsky130_fd_sc_hd__o22ai_2_0 sky130_fd_sc_hd__a31o_2_7/X sky130_fd_sc_hd__a21oi_2_5/Y sky130_fd_sc_hd__o22ai_2_0/Y sky130_fd_sc_hd__xor2_2_0/B sky130_fd_sc_hd__and3_2_2/B VGND VPWR VPWR VGND sky130_fd_sc_hd__o22ai_2
Xsky130_fd_sc_hd__a22o_2_16 sky130_fd_sc_hd__o211a_2_10/X sky130_fd_sc_hd__nor3b_2_2/Y sky130_fd_sc_hd__o31a_2_7/A2 sky130_fd_sc_hd__and2b_2_19/X sky130_fd_sc_hd__nor3_2_3/Y VPWR VGND VPWR VGND sky130_fd_sc_hd__a22o_2
Xsky130_fd_sc_hd__a31o_2_0 sky130_fd_sc_hd__a31o_2_0/X sky130_fd_sc_hd__and3_2_0/C sky130_fd_sc_hd__and3_2_1/C sky130_fd_sc_hd__or3_2_3/B sky130_fd_sc_hd__and2_2_2/A VGND VPWR VPWR VGND sky130_fd_sc_hd__a31o_2
Xsky130_fd_sc_hd__nand2_2_17 sky130_fd_sc_hd__xnor2_2_4/A sky130_fd_sc_hd__xor2_2_0/B sky130_fd_sc_hd__xor2_2_9/A VGND VPWR VPWR VGND sky130_fd_sc_hd__nand2_2
Xsky130_fd_sc_hd__nand2_2_28 sky130_fd_sc_hd__o32a_2_2/B2 sky130_fd_sc_hd__or2_2_9/X sky130_fd_sc_hd__o32a_2_2/A2 VGND VPWR sky130_fd_sc_hd__nor2_2_34/VPB VGND sky130_fd_sc_hd__nand2_2
Xsky130_fd_sc_hd__nand4_2_6 sky130_fd_sc_hd__inv_2_7/A I sky130_fd_sc_hd__nand4_2_6/Y sky130_fd_sc_hd__nand4_2_6/D sky130_fd_sc_hd__nand4_2_6/C VGND VPWR VPWR VGND sky130_fd_sc_hd__nand4_2
Xsky130_fd_sc_hd__a21o_2_15 sky130_fd_sc_hd__a21o_2_15/X sky130_fd_sc_hd__or4_2_8/A sky130_fd_sc_hd__inv_2_19/A sky130_fd_sc_hd__nor2_2_44/Y VGND VPWR VPWR VGND sky130_fd_sc_hd__a21o_2
Xsky130_fd_sc_hd__or2_2_0 sky130_fd_sc_hd__or2_2_0/B sky130_fd_sc_hd__or2_2_4/B sky130_fd_sc_hd__or2_2_2/A VPWR VGND VPWR VGND sky130_fd_sc_hd__or2_2
Xsky130_fd_sc_hd__nor2_2_6 sky130_fd_sc_hd__xor2_2_9/A sky130_fd_sc_hd__nor2_2_6/Y sky130_fd_sc_hd__xor2_2_0/B VGND VPWR VPWR VGND sky130_fd_sc_hd__nor2_2
Xsky130_fd_sc_hd__nand2b_2_14 sky130_fd_sc_hd__nand4_2_7/Y sky130_fd_sc_hd__dfrtp_2_57/D sky130_fd_sc_hd__o21a_2_19/A1 VGND VPWR VPWR VGND sky130_fd_sc_hd__nand2b_2
Xsky130_fd_sc_hd__o31a_2_8 sky130_fd_sc_hd__o31a_2_8/X sky130_fd_sc_hd__o31a_2_9/A1 sky130_fd_sc_hd__o31a_2_8/A2 sky130_fd_sc_hd__or3_2_14/X sky130_fd_sc_hd__o31a_2_8/A3 VGND VPWR VPWR VGND sky130_fd_sc_hd__o31a_2
Xsky130_fd_sc_hd__conb_1_3 sky130_fd_sc_hd__conb_1_3/LO sky130_fd_sc_hd__conb_1_3/HI VGND VPWR VPWR VGND sky130_fd_sc_hd__conb_1
Xsky130_fd_sc_hd__nor2_2_13 sky130_fd_sc_hd__or3_2_0/X sky130_fd_sc_hd__o32a_2_1/A3 sky130_fd_sc_hd__or2_2_4/A VGND VPWR VPWR VGND sky130_fd_sc_hd__nor2_2
Xsky130_fd_sc_hd__nor2_2_46 sky130_fd_sc_hd__nor2_2_46/B sky130_fd_sc_hd__nor2_2_46/Y sky130_fd_sc_hd__nor2_2_46/A VGND VPWR VPWR VGND sky130_fd_sc_hd__nor2_2
Xsky130_fd_sc_hd__nor2_2_24 sky130_fd_sc_hd__or2_2_8/B sky130_fd_sc_hd__nor2_2_24/Y sky130_fd_sc_hd__or2_2_9/A VGND VPWR sky130_fd_sc_hd__a21o_2_7/VPB VGND sky130_fd_sc_hd__nor2_2
Xsky130_fd_sc_hd__nor2_2_35 sky130_fd_sc_hd__o32a_2_2/B1 sky130_fd_sc_hd__o32a_2_2/A3 sky130_fd_sc_hd__or2_2_9/B VGND VPWR VPWR VGND sky130_fd_sc_hd__nor2_2
Xsky130_fd_sc_hd__a31o_2_20 sky130_fd_sc_hd__a31o_2_20/X sky130_fd_sc_hd__nand4_2_11/C sky130_fd_sc_hd__and4b_2_2/X I sky130_fd_sc_hd__inv_2_7/A VGND VPWR sky130_fd_sc_hd__a31o_2_20/VPB VGND sky130_fd_sc_hd__a31o_2
Xsky130_fd_sc_hd__and2_2_5 sky130_fd_sc_hd__or4_2_3/A sky130_fd_sc_hd__and4_2_0/D sky130_fd_sc_hd__or4_2_3/B VPWR VGND VPWR VGND sky130_fd_sc_hd__and2_2
Xsky130_fd_sc_hd__dfrtp_2_8 sky130_fd_sc_hd__nand4_2_3/C rst_n sky130_fd_sc_hd__o21a_2_5/X sky130_fd_sc_hd__dfrtp_2_8/CLK VGND VPWR VPWR VGND sky130_fd_sc_hd__dfrtp_2
Xsky130_fd_sc_hd__o21a_2_7 sky130_fd_sc_hd__inv_2_1/A sky130_fd_sc_hd__or4_2_1/X sky130_fd_sc_hd__o21a_2_7/A2 sky130_fd_sc_hd__o21a_2_7/X VGND VPWR VPWR VGND sky130_fd_sc_hd__o21a_2
Xsky130_fd_sc_hd__xnor2_2_6 sky130_fd_sc_hd__xnor2_2_6/Y sky130_fd_sc_hd__xnor2_2_6/A sky130_fd_sc_hd__a21o_2_6/X VGND VPWR VPWR VGND sky130_fd_sc_hd__xnor2_2
Xsky130_fd_sc_hd__o22ai_2_1 sky130_fd_sc_hd__or2_2_5/A sky130_fd_sc_hd__or3_2_3/X sky130_fd_sc_hd__o22ai_2_1/Y sky130_fd_sc_hd__or2_2_4/A sky130_fd_sc_hd__nand2_2_5/Y VGND VPWR VPWR VGND sky130_fd_sc_hd__o22ai_2
Xsky130_fd_sc_hd__a22o_2_17 sky130_fd_sc_hd__xor2_2_18/X sky130_fd_sc_hd__or3_2_17/B sky130_fd_sc_hd__a22o_2_17/X sky130_fd_sc_hd__xnor2_2_6/Y sky130_fd_sc_hd__nor3b_2_3/Y VPWR VGND VPWR VGND sky130_fd_sc_hd__a22o_2
Xsky130_fd_sc_hd__a31o_2_1 sky130_fd_sc_hd__a31o_2_1/X sky130_fd_sc_hd__nand4_2_0/C sky130_fd_sc_hd__nor4_2_0/Y I sky130_fd_sc_hd__inv_2_7/A VGND VPWR sky130_fd_sc_hd__nor4_2_0/VPB VGND sky130_fd_sc_hd__a31o_2
Xsky130_fd_sc_hd__nand2_2_18 sky130_fd_sc_hd__a21o_2_8/A2 sky130_fd_sc_hd__xnor2_2_8/A sky130_fd_sc_hd__xnor2_2_8/B VGND VPWR VPWR VGND sky130_fd_sc_hd__nand2_2
Xsky130_fd_sc_hd__nand2_2_29 sky130_fd_sc_hd__nand2_2_29/Y sky130_fd_sc_hd__or3b_2_0/A sky130_fd_sc_hd__or2_2_9/A VGND VPWR sky130_fd_sc_hd__nor2_2_34/VPB VGND sky130_fd_sc_hd__nand2_2
Xsky130_fd_sc_hd__o21ai_2_0 sky130_fd_sc_hd__or4_2_0/A sky130_fd_sc_hd__and3_2_3/C sky130_fd_sc_hd__and3_2_1/X sky130_fd_sc_hd__or3_2_4/B VGND VPWR VPWR VGND sky130_fd_sc_hd__o21ai_2
Xsky130_fd_sc_hd__nand4_2_7 sky130_fd_sc_hd__inv_2_7/A I sky130_fd_sc_hd__nand4_2_7/Y sky130_fd_sc_hd__nor4_2_1/Y sky130_fd_sc_hd__nand4_2_7/C VGND VPWR sky130_fd_sc_hd__nor4_2_1/VPB VGND sky130_fd_sc_hd__nand4_2
Xsky130_fd_sc_hd__a21o_2_16 sky130_fd_sc_hd__a21o_2_16/X sky130_fd_sc_hd__or4_2_6/A sky130_fd_sc_hd__inv_2_20/A sky130_fd_sc_hd__nor2_2_45/Y VGND VPWR VPWR VGND sky130_fd_sc_hd__a21o_2
Xsky130_fd_sc_hd__a21o_2_0 sky130_fd_sc_hd__a21o_2_0/X sky130_fd_sc_hd__or4_2_1/A sky130_fd_sc_hd__inv_2_1/A sky130_fd_sc_hd__o21a_2_7/A2 VGND VPWR VPWR VGND sky130_fd_sc_hd__a21o_2
Xsky130_fd_sc_hd__or2_2_1 sky130_fd_sc_hd__or2_2_1/B sky130_fd_sc_hd__or2_2_1/X sky130_fd_sc_hd__or2_2_1/A VPWR VGND VPWR VGND sky130_fd_sc_hd__or2_2
Xsky130_fd_sc_hd__nor2_2_7 sky130_fd_sc_hd__xor2_2_7/A sky130_fd_sc_hd__or2_2_1/B sky130_fd_sc_hd__or4_2_4/A VGND VPWR VPWR VGND sky130_fd_sc_hd__nor2_2
Xsky130_fd_sc_hd__nand2b_2_15 sky130_fd_sc_hd__nand4_2_4/Y sky130_fd_sc_hd__dfrtp_2_59/D sky130_fd_sc_hd__o21a_2_16/A1 VGND VPWR VPWR VGND sky130_fd_sc_hd__nand2b_2
Xsky130_fd_sc_hd__o31a_2_9 sky130_fd_sc_hd__o31a_2_9/X sky130_fd_sc_hd__o31a_2_9/A1 sky130_fd_sc_hd__o31a_2_9/A2 sky130_fd_sc_hd__or3_2_16/X sky130_fd_sc_hd__o31a_2_9/A3 VGND VPWR VPWR VGND sky130_fd_sc_hd__o31a_2
Xsky130_fd_sc_hd__conb_1_4 sky130_fd_sc_hd__conb_1_4/LO sky130_fd_sc_hd__conb_1_4/HI VGND VPWR sky130_fd_sc_hd__o31a_2_2/VPB VGND sky130_fd_sc_hd__conb_1
Xsky130_fd_sc_hd__nor2_2_14 sky130_fd_sc_hd__or4_2_3/D sky130_fd_sc_hd__o21a_2_6/A2 sky130_fd_sc_hd__or4_2_3/C VGND VPWR VPWR VGND sky130_fd_sc_hd__nor2_2
Xsky130_fd_sc_hd__nor2_2_47 sky130_fd_sc_hd__or3_2_17/C sky130_fd_sc_hd__o31a_2_9/A1 sky130_fd_sc_hd__or3_2_17/B VGND VPWR VPWR VGND sky130_fd_sc_hd__nor2_2
Xsky130_fd_sc_hd__nor2_2_25 sky130_fd_sc_hd__and3_2_2/B sky130_fd_sc_hd__or3_2_5/A sky130_fd_sc_hd__xor2_2_0/B VGND VPWR VPWR VGND sky130_fd_sc_hd__nor2_2
Xsky130_fd_sc_hd__nor2_2_36 sky130_fd_sc_hd__inv_2_13/Y sky130_fd_sc_hd__or3_2_9/A sky130_fd_sc_hd__or3b_2_0/A VGND VPWR VPWR VGND sky130_fd_sc_hd__nor2_2
Xsky130_fd_sc_hd__a31o_2_21 sky130_fd_sc_hd__a31o_2_21/X sky130_fd_sc_hd__nand4_2_13/C sky130_fd_sc_hd__nand4_2_13/D I sky130_fd_sc_hd__inv_2_7/A VGND VPWR VPWR VGND sky130_fd_sc_hd__a31o_2
Xsky130_fd_sc_hd__a31o_2_10 sky130_fd_sc_hd__and2b_2_9/B sky130_fd_sc_hd__nor3_2_2/B sky130_fd_sc_hd__and4_2_4/D sky130_fd_sc_hd__and4_2_4/B sky130_fd_sc_hd__inv_2_10/A VGND VPWR VPWR VGND sky130_fd_sc_hd__a31o_2
Xsky130_fd_sc_hd__and2_2_6 sky130_fd_sc_hd__or3b_2_0/A sky130_fd_sc_hd__nor3_2_1/C sky130_fd_sc_hd__or2_2_9/A VPWR VGND sky130_fd_sc_hd__o31a_2_0/VPB VGND sky130_fd_sc_hd__and2_2
Xsky130_fd_sc_hd__dfrtp_2_9 sky130_fd_sc_hd__inv_2_3/A rst_n sky130_fd_sc_hd__o21a_2_6/X sky130_fd_sc_hd__clkbuf_8_0/X VGND VPWR VPWR VGND sky130_fd_sc_hd__dfrtp_2
Xsky130_fd_sc_hd__o21a_2_8 sky130_fd_sc_hd__o21a_2_8/A1 sky130_fd_sc_hd__a31o_2_2/X sky130_fd_sc_hd__o21a_2_8/A2 sky130_fd_sc_hd__o21a_2_8/X VGND VPWR VPWR VGND sky130_fd_sc_hd__o21a_2
Xsky130_fd_sc_hd__xnor2_2_7 sky130_fd_sc_hd__or3_2_7/A sky130_fd_sc_hd__xor2_2_5/A sky130_fd_sc_hd__xor2_2_5/B VGND VPWR VPWR VGND sky130_fd_sc_hd__xnor2_2
Xsky130_fd_sc_hd__or3_2_10 sky130_fd_sc_hd__or3_2_10/A sky130_fd_sc_hd__or3_2_17/B sky130_fd_sc_hd__or3_2_10/X sky130_fd_sc_hd__or3_2_17/C VGND VPWR VPWR VGND sky130_fd_sc_hd__or3_2
Xsky130_fd_sc_hd__a22o_2_18 sky130_fd_sc_hd__xnor2_2_22/Y sky130_fd_sc_hd__or3_2_17/B sky130_fd_sc_hd__o31a_2_7/A3 sky130_fd_sc_hd__and2_2_8/X sky130_fd_sc_hd__nor3b_2_3/Y VPWR VGND VPWR VGND sky130_fd_sc_hd__a22o_2
Xsky130_fd_sc_hd__a31o_2_2 sky130_fd_sc_hd__a31o_2_2/X sky130_fd_sc_hd__nand4_2_2/C sky130_fd_sc_hd__nand4_2_2/D I sky130_fd_sc_hd__inv_2_7/A VGND VPWR VPWR VGND sky130_fd_sc_hd__a31o_2
Xsky130_fd_sc_hd__nand2_2_19 sky130_fd_sc_hd__and2_2_8/A sky130_fd_sc_hd__or3b_2_0/A sky130_fd_sc_hd__or2_2_9/A VGND VPWR VPWR VGND sky130_fd_sc_hd__nand2_2
Xsky130_fd_sc_hd__and4bb_2_0 sky130_fd_sc_hd__xor2_2_7/A sky130_fd_sc_hd__xor2_2_9/A sky130_fd_sc_hd__xor2_2_0/B sky130_fd_sc_hd__and4bb_2_0/X sky130_fd_sc_hd__xor2_2_4/A VGND VPWR VPWR VGND sky130_fd_sc_hd__and4bb_2
Xsky130_fd_sc_hd__o21ai_2_1 sky130_fd_sc_hd__or4_2_0/X sky130_fd_sc_hd__o21ai_2_1/Y sky130_fd_sc_hd__o32a_2_0/X sky130_fd_sc_hd__or2_2_5/A VGND VPWR VPWR VGND sky130_fd_sc_hd__o21ai_2
Xsky130_fd_sc_hd__nand4_2_8 sky130_fd_sc_hd__inv_2_7/A I sky130_fd_sc_hd__nand4_2_8/Y sky130_fd_sc_hd__nand4_2_8/D sky130_fd_sc_hd__nand4_2_8/C VGND VPWR VPWR VGND sky130_fd_sc_hd__nand4_2
Xsky130_fd_sc_hd__a21o_2_17 sky130_fd_sc_hd__a21o_2_17/X sky130_fd_sc_hd__or2_2_9/B sky130_fd_sc_hd__or2_2_9/A sky130_fd_sc_hd__or3b_2_0/A VGND VPWR sky130_fd_sc_hd__and2_2_16/VPB VGND sky130_fd_sc_hd__a21o_2
Xsky130_fd_sc_hd__a21o_2_1 sky130_fd_sc_hd__a21o_2_1/X sky130_fd_sc_hd__or4_2_2/A sky130_fd_sc_hd__inv_2_2/A sky130_fd_sc_hd__o21a_2_9/A2 VGND VPWR VPWR VGND sky130_fd_sc_hd__a21o_2
Xsky130_fd_sc_hd__or2_2_2 sky130_fd_sc_hd__or3_2_2/B sky130_fd_sc_hd__or3_2_3/C sky130_fd_sc_hd__or2_2_2/A VPWR VGND VPWR VGND sky130_fd_sc_hd__or2_2
Xsky130_fd_sc_hd__nor2_2_8 sky130_fd_sc_hd__or2_2_1/X sky130_fd_sc_hd__or3_2_3/A sky130_fd_sc_hd__nor2_2_8/A VGND VPWR VPWR VGND sky130_fd_sc_hd__nor2_2
Xsky130_fd_sc_hd__nand2b_2_16 sky130_fd_sc_hd__nand4_2_9/Y sky130_fd_sc_hd__dfrtp_2_66/D sky130_fd_sc_hd__o21a_2_21/A1 VGND VPWR VPWR VGND sky130_fd_sc_hd__nand2b_2
Xsky130_fd_sc_hd__conb_1_5 sky130_fd_sc_hd__conb_1_5/LO sky130_fd_sc_hd__conb_1_5/HI VGND VPWR VPWR VGND sky130_fd_sc_hd__conb_1
Xsky130_fd_sc_hd__nor2_2_37 sky130_fd_sc_hd__or2_2_8/B sky130_fd_sc_hd__or3_2_9/C sky130_fd_sc_hd__or2_2_9/B VGND VPWR VPWR VGND sky130_fd_sc_hd__nor2_2
Xsky130_fd_sc_hd__nor2_2_26 sky130_fd_sc_hd__or2_2_4/A sky130_fd_sc_hd__nor2_2_26/Y sky130_fd_sc_hd__nor2_2_5/A VGND VPWR VPWR VGND sky130_fd_sc_hd__nor2_2
Xsky130_fd_sc_hd__nor2_2_15 sky130_fd_sc_hd__or4_2_1/D sky130_fd_sc_hd__o21a_2_7/A2 sky130_fd_sc_hd__or4_2_1/C VGND VPWR VPWR VGND sky130_fd_sc_hd__nor2_2
Xsky130_fd_sc_hd__nor2_2_48 sky130_fd_sc_hd__o21ba_2_1/X sky130_fd_sc_hd__nor3_2_3/B sky130_fd_sc_hd__or4b_2_8/A VGND VPWR VPWR VGND sky130_fd_sc_hd__nor2_2
Xsky130_fd_sc_hd__nand3b_2_0 sky130_fd_sc_hd__and3_2_7/C sky130_fd_sc_hd__xor2_2_0/B sky130_fd_sc_hd__xor2_2_9/A sky130_fd_sc_hd__xor2_2_4/A VGND VPWR VPWR VGND sky130_fd_sc_hd__nand3b_2
Xsky130_fd_sc_hd__a31o_2_22 sky130_fd_sc_hd__a31o_2_22/X sky130_fd_sc_hd__nand4_2_12/C sky130_fd_sc_hd__nand4_2_12/D I sky130_fd_sc_hd__inv_2_7/A VGND VPWR VPWR VGND sky130_fd_sc_hd__a31o_2
Xsky130_fd_sc_hd__a31o_2_11 sky130_fd_sc_hd__a31o_2_11/X sky130_fd_sc_hd__inv_2_6/A sky130_fd_sc_hd__mux2_1_7/X sky130_fd_sc_hd__inv_2_9/A sky130_fd_sc_hd__inv_2_7/A VGND VPWR VPWR VGND sky130_fd_sc_hd__a31o_2
Xsky130_fd_sc_hd__and2_2_7 sky130_fd_sc_hd__or2_2_9/A sky130_fd_sc_hd__and2_2_7/X sky130_fd_sc_hd__and2_2_7/B VPWR VGND VPWR VGND sky130_fd_sc_hd__and2_2
Xsky130_fd_sc_hd__o21a_2_9 sky130_fd_sc_hd__inv_2_2/A sky130_fd_sc_hd__or4_2_2/X sky130_fd_sc_hd__o21a_2_9/A2 sky130_fd_sc_hd__o21a_2_9/X VGND VPWR VPWR VGND sky130_fd_sc_hd__o21a_2
Xsky130_fd_sc_hd__xnor2_2_8 sky130_fd_sc_hd__xor2_2_2/B sky130_fd_sc_hd__xnor2_2_8/A sky130_fd_sc_hd__xnor2_2_8/B VGND VPWR VPWR VGND sky130_fd_sc_hd__xnor2_2
Xsky130_fd_sc_hd__or3_2_11 sky130_fd_sc_hd__or3_2_11/A sky130_fd_sc_hd__or3_2_17/B sky130_fd_sc_hd__or3_2_11/X sky130_fd_sc_hd__or3_2_17/C VGND VPWR VPWR VGND sky130_fd_sc_hd__or3_2
Xsky130_fd_sc_hd__a22o_2_19 sky130_fd_sc_hd__xor2_2_20/X sky130_fd_sc_hd__or3_2_17/B sky130_fd_sc_hd__o31a_2_8/A3 sky130_fd_sc_hd__nor2_2_23/Y sky130_fd_sc_hd__nor3b_2_3/Y VPWR VGND VPWR VGND sky130_fd_sc_hd__a22o_2
Xsky130_fd_sc_hd__a2111oi_2_0 sky130_fd_sc_hd__nor2_2_33/Y sky130_fd_sc_hd__and3_2_17/C sky130_fd_sc_hd__or2_2_9/B sky130_fd_sc_hd__or3b_2_0/A sky130_fd_sc_hd__a22o_2_13/A1 sky130_fd_sc_hd__or2_2_8/B VGND VPWR VPWR VGND sky130_fd_sc_hd__a2111oi_2
Xsky130_fd_sc_hd__a31o_2_3 sky130_fd_sc_hd__a31o_2_3/X sky130_fd_sc_hd__nand4_2_1/C sky130_fd_sc_hd__nand4_2_1/D I sky130_fd_sc_hd__inv_2_7/A VGND VPWR VPWR VGND sky130_fd_sc_hd__a31o_2
Xsky130_fd_sc_hd__and4bb_2_1 sky130_fd_sc_hd__or4b_2_2/C sky130_fd_sc_hd__or4b_2_3/B sky130_fd_sc_hd__or4b_2_3/C sky130_fd_sc_hd__nand4_2_3/D sky130_fd_sc_hd__or4b_2_3/A VGND VPWR VPWR VGND sky130_fd_sc_hd__and4bb_2
Xsky130_fd_sc_hd__o21ai_2_2 sky130_fd_sc_hd__or4_2_0/A sky130_fd_sc_hd__o21ai_2_2/Y sky130_fd_sc_hd__inv_2_0/Y sky130_fd_sc_hd__or3_2_3/B VGND VPWR sky130_fd_sc_hd__and3_2_3/VPB VGND sky130_fd_sc_hd__o21ai_2
Xsky130_fd_sc_hd__nand4_2_9 sky130_fd_sc_hd__inv_2_7/A I sky130_fd_sc_hd__nand4_2_9/Y sky130_fd_sc_hd__nand4_2_9/D sky130_fd_sc_hd__nand4_2_9/C VGND VPWR VPWR VGND sky130_fd_sc_hd__nand4_2
Xsky130_fd_sc_hd__a21o_2_18 sky130_fd_sc_hd__a21o_2_18/X sky130_fd_sc_hd__or4_2_9/A sky130_fd_sc_hd__inv_2_17/A sky130_fd_sc_hd__nor2_2_41/Y VGND VPWR VPWR VGND sky130_fd_sc_hd__a21o_2
Xsky130_fd_sc_hd__a21o_2_2 sky130_fd_sc_hd__a21o_2_2/X sky130_fd_sc_hd__or4_2_3/A sky130_fd_sc_hd__inv_2_3/A sky130_fd_sc_hd__o21a_2_6/A2 VGND VPWR VPWR VGND sky130_fd_sc_hd__a21o_2
Xsky130_fd_sc_hd__or2_2_3 sky130_fd_sc_hd__or3_2_2/B sky130_fd_sc_hd__or2_2_3/X sky130_fd_sc_hd__or2_2_4/A VPWR VGND VPWR VGND sky130_fd_sc_hd__or2_2
Xsky130_fd_sc_hd__nor2_2_9 sky130_fd_sc_hd__nor2_2_9/B sky130_fd_sc_hd__inv_2_4/A sky130_fd_sc_hd__or2_2_1/B VGND VPWR VPWR VGND sky130_fd_sc_hd__nor2_2
Xsky130_fd_sc_hd__nand2b_2_17 sky130_fd_sc_hd__nand4_2_8/Y sky130_fd_sc_hd__dfrtp_2_63/D sky130_fd_sc_hd__o21a_2_23/A1 VGND VPWR VPWR VGND sky130_fd_sc_hd__nand2b_2
Xsky130_fd_sc_hd__nor2_2_38 sky130_fd_sc_hd__or2_2_9/A sky130_fd_sc_hd__or3_2_9/B sky130_fd_sc_hd__or3b_2_0/A VGND VPWR VPWR VGND sky130_fd_sc_hd__nor2_2
Xsky130_fd_sc_hd__nor2_2_27 sky130_fd_sc_hd__o21a_2_3/A2 sky130_fd_sc_hd__o32a_2_1/B1 sky130_fd_sc_hd__nor2_2_3/B VGND VPWR VPWR VGND sky130_fd_sc_hd__nor2_2
Xsky130_fd_sc_hd__nor2_2_16 sky130_fd_sc_hd__or4_2_2/D sky130_fd_sc_hd__o21a_2_9/A2 sky130_fd_sc_hd__or4_2_2/C VGND VPWR VPWR VGND sky130_fd_sc_hd__nor2_2
Xsky130_fd_sc_hd__a31o_2_23 sky130_fd_sc_hd__a31o_2_23/X sky130_fd_sc_hd__nand4_2_10/C sky130_fd_sc_hd__nand4_2_10/D I sky130_fd_sc_hd__inv_2_7/A VGND VPWR VPWR VGND sky130_fd_sc_hd__a31o_2
Xsky130_fd_sc_hd__a31o_2_12 sky130_fd_sc_hd__a31o_2_12/X sky130_fd_sc_hd__inv_2_11/A sky130_fd_sc_hd__a221o_2_1/X I sky130_fd_sc_hd__inv_2_7/A VGND VPWR VPWR VGND sky130_fd_sc_hd__a31o_2
Xsky130_fd_sc_hd__and2_2_8 sky130_fd_sc_hd__and2_2_8/A sky130_fd_sc_hd__and2_2_8/X sky130_fd_sc_hd__and2_2_8/B VPWR VGND sky130_fd_sc_hd__o22a_2_2/VPB VGND sky130_fd_sc_hd__and2_2
Xsky130_fd_sc_hd__xnor2_2_9 sky130_fd_sc_hd__or2_2_4/A sky130_fd_sc_hd__xor2_2_2/A sky130_fd_sc_hd__xor2_2_2/B VGND VPWR VPWR VGND sky130_fd_sc_hd__xnor2_2
Xsky130_fd_sc_hd__or3_2_12 sky130_fd_sc_hd__or3_2_6/X sky130_fd_sc_hd__or3_2_17/B sky130_fd_sc_hd__or3_2_12/X sky130_fd_sc_hd__or3_2_17/C VGND VPWR VPWR VGND sky130_fd_sc_hd__or3_2
Xsky130_fd_sc_hd__a31o_2_4 sky130_fd_sc_hd__a31o_2_4/X sky130_fd_sc_hd__nand4_2_3/C sky130_fd_sc_hd__nand4_2_3/D I sky130_fd_sc_hd__inv_2_7/A VGND VPWR VPWR VGND sky130_fd_sc_hd__a31o_2
Xsky130_fd_sc_hd__and4bb_2_2 sky130_fd_sc_hd__or4b_2_3/A sky130_fd_sc_hd__or4b_2_3/C sky130_fd_sc_hd__or4b_2_2/C sky130_fd_sc_hd__nand4_2_1/D sky130_fd_sc_hd__or4b_2_3/B VGND VPWR VPWR VGND sky130_fd_sc_hd__and4bb_2
Xsky130_fd_sc_hd__clkbuf_8_10 sky130_fd_sc_hd__clkbuf_8_10/X sky130_fd_sc_hd__clkbuf_8_9/A VGND VPWR VPWR VGND sky130_fd_sc_hd__clkbuf_8
Xsky130_fd_sc_hd__o21ai_2_3 sky130_fd_sc_hd__o21ai_2_3/B1 sky130_fd_sc_hd__o21ai_2_3/Y sky130_fd_sc_hd__nor2_2_40/A I VGND VPWR VPWR VGND sky130_fd_sc_hd__o21ai_2
Xsky130_fd_sc_hd__a21o_2_3 sky130_fd_sc_hd__a21o_2_3/X sky130_fd_sc_hd__and3_2_3/X sky130_fd_sc_hd__or2_2_5/A sky130_fd_sc_hd__a21o_2_3/A2 VGND VPWR VPWR VGND sky130_fd_sc_hd__a21o_2
Xsky130_fd_sc_hd__or2_2_4 sky130_fd_sc_hd__or2_2_4/B sky130_fd_sc_hd__or2_2_4/X sky130_fd_sc_hd__or2_2_4/A VPWR VGND VPWR VGND sky130_fd_sc_hd__or2_2
Xsky130_fd_sc_hd__nand2b_2_18 sky130_fd_sc_hd__o21a_2_24/A2 sky130_fd_sc_hd__dfrtp_2_67/D sky130_fd_sc_hd__o21a_2_24/A1 VGND VPWR sky130_fd_sc_hd__a31o_2_20/VPB VGND sky130_fd_sc_hd__nand2b_2
Xsky130_fd_sc_hd__nor2_2_17 sky130_fd_sc_hd__and3_2_2/C sky130_fd_sc_hd__or3_2_5/B sky130_fd_sc_hd__and3_2_2/A VGND VPWR VPWR VGND sky130_fd_sc_hd__nor2_2
Xsky130_fd_sc_hd__nor2_2_28 sky130_fd_sc_hd__and2_2_2/A sky130_fd_sc_hd__or3_2_1/B sky130_fd_sc_hd__or3_2_3/B VGND VPWR VPWR VGND sky130_fd_sc_hd__nor2_2
Xsky130_fd_sc_hd__nor2_2_39 sky130_fd_sc_hd__inv_2_7/A sky130_fd_sc_hd__nor2_2_39/Y sky130_fd_sc_hd__or2_2_10/A VGND VPWR VPWR VGND sky130_fd_sc_hd__nor2_2
Xsky130_fd_sc_hd__a31o_2_13 sky130_fd_sc_hd__a31o_2_13/X sky130_fd_sc_hd__or2_2_11/A sky130_fd_sc_hd__inv_2_7/A sky130_fd_sc_hd__inv_2_9/A sky130_fd_sc_hd__nor2_2_29/Y VGND VPWR VPWR VGND sky130_fd_sc_hd__a31o_2
Xsky130_fd_sc_hd__a31o_2_24 sky130_fd_sc_hd__a31o_2_24/X sky130_fd_sc_hd__nand4_2_9/C sky130_fd_sc_hd__nand4_2_9/D I sky130_fd_sc_hd__inv_2_7/A VGND VPWR VPWR VGND sky130_fd_sc_hd__a31o_2
Xsky130_fd_sc_hd__and2_2_9 sky130_fd_sc_hd__and4_2_3/C sky130_fd_sc_hd__and4_2_4/B sky130_fd_sc_hd__nor3_2_2/A VPWR VGND VPWR VGND sky130_fd_sc_hd__and2_2
Xsky130_fd_sc_hd__or3_2_13 sky130_fd_sc_hd__or3_2_13/A sky130_fd_sc_hd__or3_2_17/B sky130_fd_sc_hd__or3_2_13/X sky130_fd_sc_hd__or3_2_17/C VGND VPWR VPWR VGND sky130_fd_sc_hd__or3_2
Xsky130_fd_sc_hd__a31o_2_5 sky130_fd_sc_hd__a31o_2_5/X sky130_fd_sc_hd__xor2_2_5/X sky130_fd_sc_hd__a31o_2_5/A3 sky130_fd_sc_hd__or2_2_5/A sky130_fd_sc_hd__a31o_2_5/A2 VGND VPWR VPWR VGND sky130_fd_sc_hd__a31o_2
Xsky130_fd_sc_hd__xnor2_2_20 sky130_fd_sc_hd__xnor2_2_21/B sky130_fd_sc_hd__or2_2_12/A sky130_fd_sc_hd__xor2_2_20/A VGND VPWR VPWR VGND sky130_fd_sc_hd__xnor2_2
Xsky130_fd_sc_hd__and4bb_2_3 sky130_fd_sc_hd__or4b_2_3/B sky130_fd_sc_hd__or4b_2_3/C sky130_fd_sc_hd__or4b_2_2/C sky130_fd_sc_hd__nand4_2_2/D sky130_fd_sc_hd__or4b_2_3/A VGND VPWR VPWR VGND sky130_fd_sc_hd__and4bb_2
Xsky130_fd_sc_hd__clkbuf_8_11 sky130_fd_sc_hd__clkbuf_8_11/X sky130_fd_sc_hd__clkbuf_8_9/A VGND VPWR VPWR VGND sky130_fd_sc_hd__clkbuf_8
Xsky130_fd_sc_hd__o21ai_2_4 sky130_fd_sc_hd__a211o_2_3/X sky130_fd_sc_hd__o21ai_2_4/Y sky130_fd_sc_hd__o32a_2_2/B2 sky130_fd_sc_hd__inv_2_12/Y VGND VPWR VPWR VGND sky130_fd_sc_hd__o21ai_2
Xsky130_fd_sc_hd__nand3_2_0 sky130_fd_sc_hd__xor2_2_9/A sky130_fd_sc_hd__nand3_2_0/Y sky130_fd_sc_hd__xor2_2_4/A sky130_fd_sc_hd__inv_2_5/A VGND VPWR VPWR VGND sky130_fd_sc_hd__nand3_2
Xsky130_fd_sc_hd__mux2_1_0 sky130_fd_sc_hd__or4_2_0/A sky130_fd_sc_hd__a31o_2_0/X sky130_fd_sc_hd__o21a_2_3/X sky130_fd_sc_hd__mux2_1_0/X VGND VPWR VPWR VGND sky130_fd_sc_hd__mux2_1
Xsky130_fd_sc_hd__a21o_2_4 sky130_fd_sc_hd__xor2_2_5/B sky130_fd_sc_hd__a21oi_2_6/Y sky130_fd_sc_hd__xnor2_2_4/A sky130_fd_sc_hd__or3_2_5/B VGND VPWR VPWR VGND sky130_fd_sc_hd__a21o_2
Xsky130_fd_sc_hd__or2_2_5 sky130_fd_sc_hd__or3_2_1/B sky130_fd_sc_hd__or2_2_5/X sky130_fd_sc_hd__or2_2_5/A VPWR VGND VPWR VGND sky130_fd_sc_hd__or2_2
Xsky130_fd_sc_hd__nand2b_2_19 sky130_fd_sc_hd__o21a_2_25/A2 sky130_fd_sc_hd__dfrtp_2_68/D sky130_fd_sc_hd__o21a_2_25/A1 VGND VPWR VPWR VGND sky130_fd_sc_hd__nand2b_2
Xsky130_fd_sc_hd__and2b_2_0 sky130_fd_sc_hd__or2_2_0/B sky130_fd_sc_hd__nor2_2_9/B sky130_fd_sc_hd__xor2_2_3/B VPWR VGND VPWR VGND sky130_fd_sc_hd__and2b_2
Xsky130_fd_sc_hd__nor2_2_18 sky130_fd_sc_hd__xor2_2_5/B sky130_fd_sc_hd__nor2_2_20/A sky130_fd_sc_hd__xor2_2_5/A VGND VPWR VPWR VGND sky130_fd_sc_hd__nor2_2
Xsky130_fd_sc_hd__nor2_2_29 sky130_fd_sc_hd__and3_2_7/C sky130_fd_sc_hd__nor2_2_29/Y sky130_fd_sc_hd__xor2_2_7/A VGND VPWR VPWR VGND sky130_fd_sc_hd__nor2_2
Xsky130_fd_sc_hd__a31o_2_14 sky130_fd_sc_hd__a31o_2_14/X sky130_fd_sc_hd__a22o_2_4/X sky130_fd_sc_hd__or2_2_12/X sky130_fd_sc_hd__and2b_2_16/X sky130_fd_sc_hd__nand2_2_38/Y VGND VPWR VPWR VGND sky130_fd_sc_hd__a31o_2
Xsky130_fd_sc_hd__a31o_2_25 sky130_fd_sc_hd__a31o_2_25/X sky130_fd_sc_hd__nand4_2_5/C sky130_fd_sc_hd__nand4_2_5/D I sky130_fd_sc_hd__inv_2_7/A VGND VPWR VPWR VGND sky130_fd_sc_hd__a31o_2
Xsky130_fd_sc_hd__or3_2_14 sky130_fd_sc_hd__or3_2_14/A sky130_fd_sc_hd__or3_2_17/B sky130_fd_sc_hd__or3_2_14/X sky130_fd_sc_hd__or3_2_17/C VGND VPWR VPWR VGND sky130_fd_sc_hd__or3_2
Xsky130_fd_sc_hd__a31o_2_6 sky130_fd_sc_hd__or3_2_11/A sky130_fd_sc_hd__nor3_2_0/Y sky130_fd_sc_hd__nor2_2_24/Y sky130_fd_sc_hd__or3b_2_0/A sky130_fd_sc_hd__or2_2_9/B VGND VPWR VPWR VGND sky130_fd_sc_hd__a31o_2
Xsky130_fd_sc_hd__xnor2_2_10 sky130_fd_sc_hd__or4_2_0/B sky130_fd_sc_hd__xor2_2_6/A sky130_fd_sc_hd__xor2_2_6/B VGND VPWR VPWR VGND sky130_fd_sc_hd__xnor2_2
Xsky130_fd_sc_hd__xnor2_2_21 sky130_fd_sc_hd__xnor2_2_21/Y sky130_fd_sc_hd__a22o_2_4/B2 sky130_fd_sc_hd__xnor2_2_21/B VGND VPWR VPWR VGND sky130_fd_sc_hd__xnor2_2
Xsky130_fd_sc_hd__and4bb_2_4 sky130_fd_sc_hd__or2_2_9/B sky130_fd_sc_hd__or3b_2_0/A sky130_fd_sc_hd__or2_2_8/B sky130_fd_sc_hd__or3_2_14/A sky130_fd_sc_hd__or2_2_9/A VGND VPWR VPWR VGND sky130_fd_sc_hd__and4bb_2
Xsky130_fd_sc_hd__clkbuf_8_12 sky130_fd_sc_hd__dfxtp_2_2/CLK sky130_fd_sc_hd__clkbuf_8_9/A VGND VPWR sky130_fd_sc_hd__clkbuf_8_12/VPB VGND sky130_fd_sc_hd__clkbuf_8
Xsky130_fd_sc_hd__o21ai_2_5 sky130_fd_sc_hd__or2_2_8/B sky130_fd_sc_hd__o21ai_2_5/Y sky130_fd_sc_hd__or2_2_9/B sky130_fd_sc_hd__or2_2_9/A VGND VPWR sky130_fd_sc_hd__or2_2_8/VPB VGND sky130_fd_sc_hd__o21ai_2
Xsky130_fd_sc_hd__nand3_2_1 sky130_fd_sc_hd__or2_2_9/B sky130_fd_sc_hd__nand3_2_1/Y sky130_fd_sc_hd__or2_2_9/A sky130_fd_sc_hd__or3b_2_0/A VGND VPWR VPWR VGND sky130_fd_sc_hd__nand3_2
Xsky130_fd_sc_hd__mux2_1_1 sky130_fd_sc_hd__or3_2_3/B sky130_fd_sc_hd__or4_2_0/C sky130_fd_sc_hd__or3_2_0/X sky130_fd_sc_hd__mux2_1_1/X VGND VPWR VPWR VGND sky130_fd_sc_hd__mux2_1
Xsky130_fd_sc_hd__a21o_2_5 sky130_fd_sc_hd__xor2_2_6/A sky130_fd_sc_hd__nor2_2_21/A sky130_fd_sc_hd__xor2_2_8/A sky130_fd_sc_hd__xor2_2_8/B VGND VPWR VPWR VGND sky130_fd_sc_hd__a21o_2
Xsky130_fd_sc_hd__o32ai_2_0 sky130_fd_sc_hd__o31a_2_0/A1 sky130_fd_sc_hd__o32ai_2_0/B1 sky130_fd_sc_hd__o31a_2_0/A2 sky130_fd_sc_hd__and2_2_7/X sky130_fd_sc_hd__o32ai_2_0/Y sky130_fd_sc_hd__or3b_2_0/A VGND VPWR VPWR VGND sky130_fd_sc_hd__o32ai_2
Xsky130_fd_sc_hd__or2_2_6 sky130_fd_sc_hd__or2_2_6/B sky130_fd_sc_hd__or2_2_6/X sky130_fd_sc_hd__or3_2_1/C VPWR VGND VPWR VGND sky130_fd_sc_hd__or2_2
Xsky130_fd_sc_hd__o21ba_2_0 sky130_fd_sc_hd__nor2_2_5/Y sky130_fd_sc_hd__or2_2_4/A sky130_fd_sc_hd__o21ba_2_0/X sky130_fd_sc_hd__nand2_2_9/Y VGND VPWR VPWR VGND sky130_fd_sc_hd__o21ba_2
Xsky130_fd_sc_hd__and2b_2_1 sky130_fd_sc_hd__and4_2_0/B sky130_fd_sc_hd__o21a_2_4/A1 sky130_fd_sc_hd__nand4_2_0/C VPWR VGND sky130_fd_sc_hd__nand4_2_0/VPB VGND sky130_fd_sc_hd__and2b_2
Xsky130_fd_sc_hd__or4bb_2_0 sky130_fd_sc_hd__or4_2_4/A sky130_fd_sc_hd__or4bb_2_0/X sky130_fd_sc_hd__or4_2_4/C sky130_fd_sc_hd__or4_2_4/B sky130_fd_sc_hd__or4_2_4/D VPWR VGND VPWR VGND sky130_fd_sc_hd__or4bb_2
Xsky130_fd_sc_hd__nor2_2_19 sky130_fd_sc_hd__xnor2_2_8/B sky130_fd_sc_hd__nor2_2_19/Y sky130_fd_sc_hd__xnor2_2_8/A VGND VPWR VPWR VGND sky130_fd_sc_hd__nor2_2
Xsky130_fd_sc_hd__a31o_2_15 sky130_fd_sc_hd__a31o_2_15/X sky130_fd_sc_hd__a22oi_2_0/Y sky130_fd_sc_hd__nand2_2_29/Y sky130_fd_sc_hd__or2_2_9/B sky130_fd_sc_hd__inv_2_13/Y VGND VPWR VPWR VGND sky130_fd_sc_hd__a31o_2
Xsky130_fd_sc_hd__nand4_2_10 sky130_fd_sc_hd__inv_2_7/A I sky130_fd_sc_hd__o21a_2_28/A2 sky130_fd_sc_hd__nand4_2_10/D sky130_fd_sc_hd__nand4_2_10/C VGND VPWR VPWR VGND sky130_fd_sc_hd__nand4_2
Xsky130_fd_sc_hd__or3_2_15 sky130_fd_sc_hd__or3_2_15/A sky130_fd_sc_hd__or3_2_17/B sky130_fd_sc_hd__or3_2_15/X sky130_fd_sc_hd__or3_2_17/C VGND VPWR VPWR VGND sky130_fd_sc_hd__or3_2
Xsky130_fd_sc_hd__a31o_2_7 sky130_fd_sc_hd__a31o_2_7/X sky130_fd_sc_hd__or3_2_5/B sky130_fd_sc_hd__xor2_2_4/A sky130_fd_sc_hd__xor2_2_0/B sky130_fd_sc_hd__xor2_2_9/A VGND VPWR VPWR VGND sky130_fd_sc_hd__a31o_2
Xsky130_fd_sc_hd__xnor2_2_22 sky130_fd_sc_hd__xnor2_2_22/Y sky130_fd_sc_hd__or2_2_12/A sky130_fd_sc_hd__o21ai_2_4/Y VGND VPWR VPWR VGND sky130_fd_sc_hd__xnor2_2
Xsky130_fd_sc_hd__xnor2_2_11 sky130_fd_sc_hd__xnor2_2_11/Y sky130_fd_sc_hd__and4_2_3/C sky130_fd_sc_hd__xnor2_2_11/B VGND VPWR VPWR VGND sky130_fd_sc_hd__xnor2_2
Xsky130_fd_sc_hd__and4bb_2_5 sky130_fd_sc_hd__and4_2_3/B sky130_fd_sc_hd__nor3_2_2/B sky130_fd_sc_hd__or3_2_8/C sky130_fd_sc_hd__and3_2_10/A sky130_fd_sc_hd__or3_2_8/B VGND VPWR VPWR VGND sky130_fd_sc_hd__and4bb_2
Xsky130_fd_sc_hd__clkbuf_8_13 sky130_fd_sc_hd__clkbuf_4_9/A sky130_fd_sc_hd__clkbuf_8_9/A VGND VPWR sky130_fd_sc_hd__clkbuf_4_9/VPB VGND sky130_fd_sc_hd__clkbuf_8
Xsky130_fd_sc_hd__nor3b_2_0 sky130_fd_sc_hd__nor2_2_40/A sky130_fd_sc_hd__o22a_2_3/B1 sky130_fd_sc_hd__inv_2_7/A sky130_fd_sc_hd__nor3b_2_0/B VGND VPWR VPWR VGND sky130_fd_sc_hd__nor3b_2
Xsky130_fd_sc_hd__mux2_1_2 sky130_fd_sc_hd__or4_2_0/A sky130_fd_sc_hd__a22o_2_0/X sky130_fd_sc_hd__or2_2_6/X sky130_fd_sc_hd__mux2_1_2/X VGND VPWR VPWR VGND sky130_fd_sc_hd__mux2_1
Xsky130_fd_sc_hd__a21o_2_6 sky130_fd_sc_hd__a21o_2_6/X sky130_fd_sc_hd__or2_2_9/A sky130_fd_sc_hd__and2_2_7/B sky130_fd_sc_hd__a21o_2_6/A2 VGND VPWR VPWR VGND sky130_fd_sc_hd__a21o_2
Xsky130_fd_sc_hd__or2_2_7 I sky130_fd_sc_hd__or2_2_7/X sky130_fd_sc_hd__or2_2_7/A VPWR VGND VPWR VGND sky130_fd_sc_hd__or2_2
Xsky130_fd_sc_hd__o21ba_2_1 sky130_fd_sc_hd__or4b_2_8/C success sky130_fd_sc_hd__o21ba_2_1/X sky130_fd_sc_hd__a32o_2_3/B1 VGND VPWR VPWR VGND sky130_fd_sc_hd__o21ba_2
Xsky130_fd_sc_hd__and2b_2_2 sky130_fd_sc_hd__and4_2_0/C sky130_fd_sc_hd__o21a_2_5/A1 sky130_fd_sc_hd__nand4_2_3/C VPWR VGND VPWR VGND sky130_fd_sc_hd__and2b_2
Xsky130_fd_sc_hd__o31ai_2_0 sky130_fd_sc_hd__or2_2_4/A sky130_fd_sc_hd__o32a_2_1/B2 sky130_fd_sc_hd__or4_2_0/A sky130_fd_sc_hd__inv_2_0/Y sky130_fd_sc_hd__or3_2_2/C VGND VPWR VPWR VGND sky130_fd_sc_hd__o31ai_2
Xsky130_fd_sc_hd__a31o_2_16 sky130_fd_sc_hd__a31o_2_16/X sky130_fd_sc_hd__nand4_2_6/C sky130_fd_sc_hd__nand4_2_6/D I sky130_fd_sc_hd__inv_2_7/A VGND VPWR VPWR VGND sky130_fd_sc_hd__a31o_2
Xsky130_fd_sc_hd__nand4_2_11 sky130_fd_sc_hd__inv_2_7/A I sky130_fd_sc_hd__o21a_2_24/A2 sky130_fd_sc_hd__and4b_2_2/X sky130_fd_sc_hd__nand4_2_11/C VGND VPWR VPWR VGND sky130_fd_sc_hd__nand4_2
Xsky130_fd_sc_hd__or3_2_16 sky130_fd_sc_hd__or3_2_16/A sky130_fd_sc_hd__or3_2_17/B sky130_fd_sc_hd__or3_2_16/X sky130_fd_sc_hd__or3_2_17/C VGND VPWR VPWR VGND sky130_fd_sc_hd__or3_2
Xsky130_fd_sc_hd__a31o_2_8 sky130_fd_sc_hd__a31o_2_8/X sky130_fd_sc_hd__xor2_2_0/B sky130_fd_sc_hd__xor2_2_7/A sky130_fd_sc_hd__inv_2_9/A sky130_fd_sc_hd__inv_2_7/A VGND VPWR VPWR VGND sky130_fd_sc_hd__a31o_2
Xsky130_fd_sc_hd__xnor2_2_23 sky130_fd_sc_hd__or2_2_12/B sky130_fd_sc_hd__a22o_2_4/B2 sky130_fd_sc_hd__xnor2_2_26/A VGND VPWR VPWR VGND sky130_fd_sc_hd__xnor2_2
Xsky130_fd_sc_hd__and4bb_2_6 sky130_fd_sc_hd__or4_2_4/A sky130_fd_sc_hd__or4_2_4/D sky130_fd_sc_hd__or4_2_4/C sky130_fd_sc_hd__inv_2_9/A sky130_fd_sc_hd__or4_2_4/B VGND VPWR VPWR VGND sky130_fd_sc_hd__and4bb_2
Xsky130_fd_sc_hd__xnor2_2_12 sky130_fd_sc_hd__nor2_2_31/B sky130_fd_sc_hd__or4_2_4/A sky130_fd_sc_hd__inv_2_7/A VGND VPWR VPWR VGND sky130_fd_sc_hd__xnor2_2
Xsky130_fd_sc_hd__clkbuf_8_14 sky130_fd_sc_hd__dfxtp_2_3/CLK sky130_fd_sc_hd__clkbuf_8_9/A VGND VPWR sky130_fd_sc_hd__clkbuf_8_14/VPB VGND sky130_fd_sc_hd__clkbuf_8
Xsky130_fd_sc_hd__nor3b_2_1 sky130_fd_sc_hd__or2_2_9/A sky130_fd_sc_hd__o31a_2_2/A3 sky130_fd_sc_hd__or3b_2_0/A sky130_fd_sc_hd__or2_2_9/B VGND VPWR VPWR VGND sky130_fd_sc_hd__nor3b_2
Xsky130_fd_sc_hd__clkbuf_8_0 sky130_fd_sc_hd__clkbuf_8_0/X sky130_fd_sc_hd__clkbuf_8_9/A VGND VPWR VPWR VGND sky130_fd_sc_hd__clkbuf_8
Xsky130_fd_sc_hd__mux2_1_3 sky130_fd_sc_hd__or2_2_5/A sky130_fd_sc_hd__mux2_1_0/X sky130_fd_sc_hd__o32a_2_1/X sky130_fd_sc_hd__mux2_1_3/X VGND VPWR VPWR VGND sky130_fd_sc_hd__mux2_1
Xsky130_fd_sc_hd__a21o_2_7 sky130_fd_sc_hd__or3_2_10/A sky130_fd_sc_hd__or3_2_6/C sky130_fd_sc_hd__or3b_2_0/A sky130_fd_sc_hd__nor2_2_24/Y VGND VPWR sky130_fd_sc_hd__a21o_2_7/VPB VGND sky130_fd_sc_hd__a21o_2
.ends
